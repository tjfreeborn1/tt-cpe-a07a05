* cpe_a07 v4b layout-realistic
.subckt cpe_a07 t
XR1_0 t 1_s1 0 sky130_fd_pr__res_xhigh_po_0p35 L=98.453 mult=1
XR1_1 1_s1 1_s2 0 sky130_fd_pr__res_xhigh_po_0p35 L=98.453 mult=1
XR1_2 1_s2 1_s3 0 sky130_fd_pr__res_xhigh_po_0p35 L=98.453 mult=1
XR1_3 1_s3 1_s4 0 sky130_fd_pr__res_xhigh_po_0p35 L=98.453 mult=1
XR1_4 1_s4 1_s5 0 sky130_fd_pr__res_xhigh_po_0p35 L=98.453 mult=1
XR1_5 1_s5 1_s6 0 sky130_fd_pr__res_xhigh_po_0p35 L=98.453 mult=1
XR1_6 1_s6 n1 0 sky130_fd_pr__res_xhigh_po_0p35 L=98.453 mult=1
XM1 0 n1 0 0 sky130_fd_pr__nfet_01v8 W=10 L=10 nf=1 m=107
XM1p 0 n1 0 0 sky130_fd_pr__nfet_01v8 W=6.133 L=10 nf=1 m=1
XK1 n1 0 sky130_fd_pr__cap_mim_m3_1 W=28.837 L=28.837 MF=11 m=11
XR2_0 t 2_s1 0 sky130_fd_pr__res_xhigh_po_0p35 L=73.019 mult=1
XR2_1 2_s1 2_s2 0 sky130_fd_pr__res_xhigh_po_0p35 L=73.019 mult=1
XR2_2 2_s2 n2 0 sky130_fd_pr__res_xhigh_po_0p35 L=73.019 mult=1
XM2 0 n2 0 0 sky130_fd_pr__nfet_01v8 W=10 L=10 nf=1 m=45
XM2p 0 n2 0 0 sky130_fd_pr__nfet_01v8 W=5.520 L=10 nf=1 m=1
XK2 n2 0 sky130_fd_pr__cap_mim_m3_1 W=27.828 L=27.828 MF=5 m=5
XR3_0 t n3 0 sky130_fd_pr__res_xhigh_po_0p35 L=57.804 mult=1
XM3 0 n3 0 0 sky130_fd_pr__nfet_01v8 W=10 L=10 nf=1 m=28
XM3p 0 n3 0 0 sky130_fd_pr__nfet_01v8 W=9.451 L=10 nf=1 m=1
XK3 n3 0 sky130_fd_pr__cap_mim_m3_1 W=28.638 L=28.638 MF=3 m=3
XR4_0 t n4 0 sky130_fd_pr__res_xhigh_po_0p35 L=14.920 mult=1
XM4 0 n4 0 0 sky130_fd_pr__nfet_01v8 W=10 L=10 nf=1 m=17
XM4p 0 n4 0 0 sky130_fd_pr__nfet_01v8 W=7.468 L=10 nf=1 m=1
XK4 n4 0 sky130_fd_pr__cap_mim_m3_1 W=27.463 L=27.463 MF=2 m=2
XR5_0 t n5 0 sky130_fd_pr__res_xhigh_po_0p35 L=2.602 mult=1
XM5 0 n5 0 0 sky130_fd_pr__nfet_01v8 W=10 L=10 nf=1 m=13
XM5p 0 n5 0 0 sky130_fd_pr__nfet_01v8 W=1.883 L=10 nf=1 m=1
XK5 n5 0 sky130_fd_pr__cap_mim_m3_1 W=23.675 L=23.675 MF=2 m=2
XRp_0 t p_s1 0 sky130_fd_pr__res_xhigh_po_0p35 L=98.426 mult=1
XRp_1 p_s1 p_s2 0 sky130_fd_pr__res_xhigh_po_0p35 L=98.426 mult=1
XRp_2 p_s2 p_s3 0 sky130_fd_pr__res_xhigh_po_0p35 L=98.426 mult=1
XRp_3 p_s3 p_s4 0 sky130_fd_pr__res_xhigh_po_0p35 L=98.426 mult=1
XRp_4 p_s4 p_s5 0 sky130_fd_pr__res_xhigh_po_0p35 L=98.426 mult=1
XRp_5 p_s5 p_s6 0 sky130_fd_pr__res_xhigh_po_0p35 L=98.426 mult=1
XRp_6 p_s6 p_s7 0 sky130_fd_pr__res_xhigh_po_0p35 L=98.426 mult=1
XRp_7 p_s7 p_s8 0 sky130_fd_pr__res_xhigh_po_0p35 L=98.426 mult=1
XRp_8 p_s8 p_s9 0 sky130_fd_pr__res_xhigh_po_0p35 L=98.426 mult=1
XRp_9 p_s9 p_s10 0 sky130_fd_pr__res_xhigh_po_0p35 L=98.426 mult=1
XRp_10 p_s10 p_s11 0 sky130_fd_pr__res_xhigh_po_0p35 L=98.426 mult=1
XRp_11 p_s11 p_s12 0 sky130_fd_pr__res_xhigh_po_0p35 L=98.426 mult=1
XRp_12 p_s12 p_s13 0 sky130_fd_pr__res_xhigh_po_0p35 L=98.426 mult=1
XRp_13 p_s13 p_s14 0 sky130_fd_pr__res_xhigh_po_0p35 L=98.426 mult=1
XRp_14 p_s14 p_s15 0 sky130_fd_pr__res_xhigh_po_0p35 L=98.426 mult=1
XRp_15 p_s15 p_s16 0 sky130_fd_pr__res_xhigh_po_0p35 L=98.426 mult=1
XRp_16 p_s16 p_s17 0 sky130_fd_pr__res_xhigh_po_0p35 L=98.426 mult=1
XRp_17 p_s17 p_s18 0 sky130_fd_pr__res_xhigh_po_0p35 L=98.426 mult=1
XRp_18 p_s18 p_s19 0 sky130_fd_pr__res_xhigh_po_0p35 L=98.426 mult=1
XRp_19 p_s19 p_s20 0 sky130_fd_pr__res_xhigh_po_0p35 L=98.426 mult=1
XRp_20 p_s20 p_s21 0 sky130_fd_pr__res_xhigh_po_0p35 L=98.426 mult=1
XRp_21 p_s21 p_s22 0 sky130_fd_pr__res_xhigh_po_0p35 L=98.426 mult=1
XRp_22 p_s22 p_s23 0 sky130_fd_pr__res_xhigh_po_0p35 L=98.426 mult=1
XRp_23 p_s23 p_s24 0 sky130_fd_pr__res_xhigh_po_0p35 L=98.426 mult=1
XRp_24 p_s24 p_s25 0 sky130_fd_pr__res_xhigh_po_0p35 L=98.426 mult=1
XRp_25 p_s25 p_s26 0 sky130_fd_pr__res_xhigh_po_0p35 L=98.426 mult=1
XRp_26 p_s26 p_s27 0 sky130_fd_pr__res_xhigh_po_0p35 L=98.426 mult=1
XRp_27 p_s27 p_s28 0 sky130_fd_pr__res_xhigh_po_0p35 L=98.426 mult=1
XRp_28 p_s28 p_s29 0 sky130_fd_pr__res_xhigh_po_0p35 L=98.426 mult=1
XRp_29 p_s29 p_s30 0 sky130_fd_pr__res_xhigh_po_0p35 L=98.426 mult=1
XRp_30 p_s30 p_s31 0 sky130_fd_pr__res_xhigh_po_0p35 L=98.426 mult=1
XRp_31 p_s31 0 0 sky130_fd_pr__res_xhigh_po_0p35 L=98.426 mult=1
.ends
