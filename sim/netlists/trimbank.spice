* trimbank: as-built (layout v1); bit tiles share one bottom-plate island per bit
.subckt trimbank t g0 g1 g2 g3 g4
XK0 t b0 sky130_fd_pr__cap_mim_m3_1 W=7.33 L=19.86 MF=1 m=1
XS0 b0 g0 0 0 sky130_fd_pr__nfet_01v8 W=3.0 L=0.15 nf=1 m=1
RL0 b0 0 1e10
XK1 t b1 sky130_fd_pr__cap_mim_m3_1 W=14.82 L=19.86 MF=1 m=1
XS1 b1 g1 0 0 sky130_fd_pr__nfet_01v8 W=6.0 L=0.15 nf=1 m=1
RL1 b1 0 1e10
XK2 t b2 sky130_fd_pr__cap_mim_m3_1 W=29.8 L=19.86 MF=1 m=1
XS2 b2 g2 0 0 sky130_fd_pr__nfet_01v8 W=12.0 L=0.15 nf=1 m=1
RL2 b2 0 1e10
XK3 t b3 sky130_fd_pr__cap_mim_m3_1 W=29.8 L=19.86 MF=2 m=2
XS3 b3 g3 0 0 sky130_fd_pr__nfet_01v8 W=24.0 L=0.15 nf=1 m=1
RL3 b3 0 1e10
XK4 t b4 sky130_fd_pr__cap_mim_m3_1 W=29.8 L=19.86 MF=4 m=4
XS4 b4 g4 0 0 sky130_fd_pr__nfet_01v8 W=48.0 L=0.15 nf=1 m=1
RL4 b4 0 1e10
.ends
