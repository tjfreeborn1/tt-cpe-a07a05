* cpe_a05 v4b layout-realistic
.subckt cpe_a05 t
XR1_0 t 1_s1 0 sky130_fd_pr__res_xhigh_po_0p35 L=51.670 mult=1
XR1_1 1_s1 n1 0 sky130_fd_pr__res_xhigh_po_0p35 L=51.670 mult=1
XM1 0 n1 0 0 sky130_fd_pr__nfet_01v8 W=10 L=10 nf=1 m=97
XM1p 0 n1 0 0 sky130_fd_pr__nfet_01v8 W=2.673 L=10 nf=1 m=1
XK1 n1 0 sky130_fd_pr__cap_mim_m3_1 W=28.754 L=28.754 MF=10 m=10
XR2_0 t n2 0 sky130_fd_pr__res_xhigh_po_0p35 L=38.771 mult=1
XM2 0 n2 0 0 sky130_fd_pr__nfet_01v8 W=10 L=10 nf=1 m=82
XM2p 0 n2 0 0 sky130_fd_pr__nfet_01v8 W=5.494 L=10 nf=1 m=1
XK2 n2 0 sky130_fd_pr__cap_mim_m3_1 W=29.616 L=29.616 MF=8 m=8
XR3_0 t n3 0 sky130_fd_pr__res_xhigh_po_0p35 L=8.823 mult=1
XM3 0 n3 0 0 sky130_fd_pr__nfet_01v8 W=10 L=10 nf=1 m=34
XM3p 0 n3 0 0 sky130_fd_pr__nfet_01v8 W=2.722 L=10 nf=1 m=1
XK3 n3 0 sky130_fd_pr__cap_mim_m3_1 W=26.987 L=26.987 MF=4 m=4
XRp_0 t p_s1 0 sky130_fd_pr__res_xhigh_po_0p35 L=59.651 mult=1
XRp_1 p_s1 0 0 sky130_fd_pr__res_xhigh_po_0p35 L=59.651 mult=1
.ends
