* PEX of tt_um_tjfreeborn1_cpe_a07a05 (Magic, C + coupling, cthresh 0.01 fF)
.subckt toppex ua[0] ua[1] ui_in[0] ui_in[1] ui_in[2] ui_in[3] ui_in[4] uio_in[0] uio_in[1] uio_in[2] uio_in[3] uio_in[4] VDPWR VGND
X0 VDPWR sky130_fd_sc_hd__buf_2_0/a_27_47# swB4/G VDPWR sky130_fd_pr__pfet_01v8_hvt ad=0.265 pd=2.53 as=0.135 ps=1.27 w=1 l=0.15
X1 swB4/G sky130_fd_sc_hd__buf_2_0/a_27_47# VDPWR VDPWR sky130_fd_pr__pfet_01v8_hvt ad=0.135 pd=1.27 as=0.149 ps=1.325 w=1 l=0.15
X2 VDPWR uio_in[4] sky130_fd_sc_hd__buf_2_0/a_27_47# VDPWR sky130_fd_pr__pfet_01v8_hvt ad=0.149 pd=1.325 as=0.1664 ps=1.8 w=0.64 l=0.15
X3 swB4/G sky130_fd_sc_hd__buf_2_0/a_27_47# VGND VGND sky130_fd_pr__nfet_01v8 ad=0.08775 pd=0.92 as=0.097 ps=0.975 w=0.65 l=0.15
X4 VGND sky130_fd_sc_hd__buf_2_0/a_27_47# swB4/G VGND sky130_fd_pr__nfet_01v8 ad=0.17225 pd=1.83 as=0.08775 ps=0.92 w=0.65 l=0.15
X5 VGND uio_in[4] sky130_fd_sc_hd__buf_2_0/a_27_47# VGND sky130_fd_pr__nfet_01v8 ad=0.097 pd=0.975 as=0.1092 ps=1.36 w=0.42 l=0.15
X6 VDPWR sky130_fd_sc_hd__buf_2_1/a_27_47# swB3/G VDPWR sky130_fd_pr__pfet_01v8_hvt ad=5.63 pd=51.8 as=0.27 ps=2.54 w=1 l=0.15
X7 swB3/G sky130_fd_sc_hd__buf_2_1/a_27_47# VDPWR VDPWR sky130_fd_pr__pfet_01v8_hvt ad=0 pd=0 as=0 ps=0 w=1 l=0.15
X8 VDPWR uio_in[3] sky130_fd_sc_hd__buf_2_1/a_27_47# VDPWR sky130_fd_pr__pfet_01v8_hvt ad=0 pd=0 as=0.1664 ps=1.8 w=0.64 l=0.15
X9 swB3/G sky130_fd_sc_hd__buf_2_1/a_27_47# VGND VGND sky130_fd_pr__nfet_01v8 ad=0.1755 pd=1.84 as=1.4017k ps=9.94234k w=0.65 l=0.15
X10 VGND sky130_fd_sc_hd__buf_2_1/a_27_47# swB3/G VGND sky130_fd_pr__nfet_01v8 ad=0 pd=0 as=0 ps=0 w=0.65 l=0.15
X11 VGND uio_in[3] sky130_fd_sc_hd__buf_2_1/a_27_47# VGND sky130_fd_pr__nfet_01v8 ad=0 pd=0 as=0.1092 ps=1.36 w=0.42 l=0.15
X12 VDPWR sky130_fd_sc_hd__buf_2_2/a_27_47# swB2/G VDPWR sky130_fd_pr__pfet_01v8_hvt ad=0 pd=0 as=0.27 ps=2.54 w=1 l=0.15
X13 swB2/G sky130_fd_sc_hd__buf_2_2/a_27_47# VDPWR VDPWR sky130_fd_pr__pfet_01v8_hvt ad=0 pd=0 as=0 ps=0 w=1 l=0.15
X14 VDPWR uio_in[2] sky130_fd_sc_hd__buf_2_2/a_27_47# VDPWR sky130_fd_pr__pfet_01v8_hvt ad=0 pd=0 as=0.1664 ps=1.8 w=0.64 l=0.15
X15 swB2/G sky130_fd_sc_hd__buf_2_2/a_27_47# VGND VGND sky130_fd_pr__nfet_01v8 ad=0.1755 pd=1.84 as=0 ps=0 w=0.65 l=0.15
X16 VGND sky130_fd_sc_hd__buf_2_2/a_27_47# swB2/G VGND sky130_fd_pr__nfet_01v8 ad=0 pd=0 as=0 ps=0 w=0.65 l=0.15
X17 VGND uio_in[2] sky130_fd_sc_hd__buf_2_2/a_27_47# VGND sky130_fd_pr__nfet_01v8 ad=0 pd=0 as=0.1092 ps=1.36 w=0.42 l=0.15
X18 VGND blk07_0/n07_3 VGND VGND sky130_fd_pr__nfet_01v8 ad=2.9 pd=20.58 as=1.45 ps=10.29 w=10 l=10
X19 VGND blk07_0/n07_3 VGND VGND sky130_fd_pr__nfet_01v8 ad=1.45 pd=10.29 as=2.9 ps=20.58 w=10 l=10
X20 VGND blk07_0/n07_3 VGND VGND sky130_fd_pr__nfet_01v8 ad=1.45 pd=10.29 as=1.45 ps=10.29 w=10 l=10
X21 VGND blk07_0/n07_3 VGND VGND sky130_fd_pr__nfet_01v8 ad=1.45 pd=10.29 as=1.45 ps=10.29 w=10 l=10
X22 VGND blk07_0/n07_3 VGND VGND sky130_fd_pr__nfet_01v8 ad=1.45 pd=10.29 as=1.45 ps=10.29 w=10 l=10
X23 VGND blk07_0/n07_4 VGND VGND sky130_fd_pr__nfet_01v8 ad=1.45 pd=10.29 as=1.45 ps=10.29 w=10 l=10
X24 VGND blk07_0/n07_4 VGND VGND sky130_fd_pr__nfet_01v8 ad=1.45 pd=10.29 as=1.45 ps=10.29 w=10 l=10
X25 VGND blk07_0/n07_4 VGND VGND sky130_fd_pr__nfet_01v8 ad=2.9 pd=20.58 as=1.45 ps=10.29 w=10 l=10
X26 VGND blk07_0/n07_4 VGND VGND sky130_fd_pr__nfet_01v8 ad=1.45 pd=10.29 as=1.45 ps=10.29 w=10 l=10
X27 VGND blk07_0/n07_4 VGND VGND sky130_fd_pr__nfet_01v8 ad=1.45 pd=10.29 as=1.45 ps=10.29 w=10 l=10
X28 VGND blk07_0/n07_4 VGND VGND sky130_fd_pr__nfet_01v8 ad=1.45 pd=10.29 as=1.45 ps=10.29 w=10 l=10
X29 VGND blk07_0/n07_4 VGND VGND sky130_fd_pr__nfet_01v8 ad=1.45 pd=10.29 as=1.45 ps=10.29 w=10 l=10
X30 VGND blk07_0/n07_4 VGND VGND sky130_fd_pr__nfet_01v8 ad=1.45 pd=10.29 as=1.45 ps=10.29 w=10 l=10
X31 VGND blk07_0/n07_4 VGND VGND sky130_fd_pr__nfet_01v8 ad=1.45 pd=10.29 as=1.45 ps=10.29 w=10 l=10
X32 VGND blk07_0/n07_4 VGND VGND sky130_fd_pr__nfet_01v8 ad=1.45 pd=10.29 as=1.45 ps=10.29 w=10 l=10
X33 VGND blk07_0/n07_4 VGND VGND sky130_fd_pr__nfet_01v8 ad=1.45 pd=10.29 as=1.45 ps=10.29 w=10 l=10
X34 VGND blk07_0/n07_4 VGND VGND sky130_fd_pr__nfet_01v8 ad=1.45 pd=10.29 as=2.9 ps=20.58 w=10 l=10
X35 VGND blk07_0/n07_4 VGND VGND sky130_fd_pr__nfet_01v8 ad=1.45 pd=10.29 as=1.45 ps=10.29 w=10 l=10
X36 VGND blk07_0/n07_4 VGND VGND sky130_fd_pr__nfet_01v8 ad=1.45 pd=10.29 as=1.45 ps=10.29 w=10 l=10
X37 VGND blk07_0/n07_4 VGND VGND sky130_fd_pr__nfet_01v8 ad=2.9 pd=20.58 as=1.45 ps=10.29 w=10 l=10
X38 VGND blk07_0/n07_4 VGND VGND sky130_fd_pr__nfet_01v8 ad=1.45 pd=10.29 as=2.9 ps=20.58 w=10 l=10
X39 VGND blk07_0/n07_4 VGND VGND sky130_fd_pr__nfet_01v8 ad=1.45 pd=10.29 as=1.45 ps=10.29 w=10 l=10
X40 VGND blk07_0/n07_4 VGND VGND sky130_fd_pr__nfet_01v8 ad=1.45 pd=10.29 as=1.45 ps=10.29 w=10 l=10
X41 VGND blk07_0/n07_5 VGND VGND sky130_fd_pr__nfet_01v8 ad=0 pd=0 as=0 ps=0 w=10 l=10
X42 VGND blk07_0/n07_5 VGND VGND sky130_fd_pr__nfet_01v8 ad=0 pd=0 as=0 ps=0 w=10 l=10
X43 VGND blk07_0/n07_5 VGND VGND sky130_fd_pr__nfet_01v8 ad=0 pd=0 as=0 ps=0 w=10 l=10
X44 VGND blk07_0/n07_5 VGND VGND sky130_fd_pr__nfet_01v8 ad=0 pd=0 as=0 ps=0 w=10 l=10
X45 VGND blk07_0/n07_5 VGND VGND sky130_fd_pr__nfet_01v8 ad=0 pd=0 as=0 ps=0 w=10 l=10
X46 VGND blk07_0/n07_5 VGND VGND sky130_fd_pr__nfet_01v8 ad=0 pd=0 as=0 ps=0 w=10 l=10
X47 VGND blk07_0/n07_5 VGND VGND sky130_fd_pr__nfet_01v8 ad=0 pd=0 as=0 ps=0 w=10 l=10
X48 VGND blk07_0/n07_5 VGND VGND sky130_fd_pr__nfet_01v8 ad=0 pd=0 as=0 ps=0 w=10 l=10
X49 VGND blk07_0/n07_5 VGND VGND sky130_fd_pr__nfet_01v8 ad=0 pd=0 as=0 ps=0 w=10 l=10
X50 VGND blk07_0/n07_5 VGND VGND sky130_fd_pr__nfet_01v8 ad=0 pd=0 as=0 ps=0 w=10 l=10
X51 VGND blk07_0/n07_5 VGND VGND sky130_fd_pr__nfet_01v8 ad=0 pd=0 as=0 ps=0 w=10 l=10
X52 VGND blk07_0/n07_5 VGND VGND sky130_fd_pr__nfet_01v8 ad=0 pd=0 as=0 ps=0 w=10 l=10
X53 VGND blk07_0/n07_5 VGND VGND sky130_fd_pr__nfet_01v8 ad=2.9 pd=20.58 as=2.9 ps=20.58 w=10 l=10
X54 VGND blk07_0/n07_1 VGND VGND sky130_fd_pr__nfet_01v8 ad=0 pd=0 as=0 ps=0 w=10 l=10
X55 VGND blk07_0/n07_1 VGND VGND sky130_fd_pr__nfet_01v8 ad=0 pd=0 as=0 ps=0 w=10 l=10
X56 VGND blk07_0/n07_1 VGND VGND sky130_fd_pr__nfet_01v8 ad=0 pd=0 as=0 ps=0 w=10 l=10
X57 VGND blk07_0/n07_1 VGND VGND sky130_fd_pr__nfet_01v8 ad=0 pd=0 as=0 ps=0 w=10 l=10
X58 VGND blk07_0/n07_1 VGND VGND sky130_fd_pr__nfet_01v8 ad=0 pd=0 as=0 ps=0 w=10 l=10
X59 VGND blk07_0/n07_1 VGND VGND sky130_fd_pr__nfet_01v8 ad=0 pd=0 as=0 ps=0 w=10 l=10
X60 VGND blk07_0/n07_1 VGND VGND sky130_fd_pr__nfet_01v8 ad=0 pd=0 as=0 ps=0 w=10 l=10
X61 VGND blk07_0/n07_1 VGND VGND sky130_fd_pr__nfet_01v8 ad=0 pd=0 as=0 ps=0 w=10 l=10
X62 VGND blk07_0/n07_1 VGND VGND sky130_fd_pr__nfet_01v8 ad=0 pd=0 as=0 ps=0 w=10 l=10
X63 VGND blk07_0/n07_1 VGND VGND sky130_fd_pr__nfet_01v8 ad=0 pd=0 as=0 ps=0 w=10 l=10
X64 VGND blk07_0/n07_1 VGND VGND sky130_fd_pr__nfet_01v8 ad=0 pd=0 as=0 ps=0 w=10 l=10
X65 VGND blk07_0/n07_1 VGND VGND sky130_fd_pr__nfet_01v8 ad=0 pd=0 as=0 ps=0 w=10 l=10
X66 VGND blk07_0/n07_1 VGND VGND sky130_fd_pr__nfet_01v8 ad=2.9 pd=20.58 as=1.45 ps=10.29 w=10 l=10
X67 VGND blk07_0/n07_1 VGND VGND sky130_fd_pr__nfet_01v8 ad=1.45 pd=10.29 as=1.45 ps=10.29 w=10 l=10
X68 VGND blk07_0/n07_1 VGND VGND sky130_fd_pr__nfet_01v8 ad=1.45 pd=10.29 as=1.45 ps=10.29 w=10 l=10
X69 VGND blk07_0/n07_1 VGND VGND sky130_fd_pr__nfet_01v8 ad=1.45 pd=10.29 as=1.45 ps=10.29 w=10 l=10
X70 VGND blk07_0/n07_1 VGND VGND sky130_fd_pr__nfet_01v8 ad=1.45 pd=10.29 as=1.45 ps=10.29 w=10 l=10
X71 VGND blk07_0/n07_1 VGND VGND sky130_fd_pr__nfet_01v8 ad=1.45 pd=10.29 as=2.9 ps=20.58 w=10 l=10
X72 VGND blk07_0/n07_1 VGND VGND sky130_fd_pr__nfet_01v8 ad=1.45 pd=10.29 as=1.45 ps=10.29 w=10 l=10
X73 VGND blk07_0/n07_1 VGND VGND sky130_fd_pr__nfet_01v8 ad=1.45 pd=10.29 as=1.45 ps=10.29 w=10 l=10
X74 VGND blk07_0/n07_1 VGND VGND sky130_fd_pr__nfet_01v8 ad=1.45 pd=10.29 as=1.45 ps=10.29 w=10 l=10
X75 VGND blk07_0/n07_1 VGND VGND sky130_fd_pr__nfet_01v8 ad=1.45 pd=10.29 as=1.45 ps=10.29 w=10 l=10
X76 VGND blk07_0/n07_1 VGND VGND sky130_fd_pr__nfet_01v8 ad=1.45 pd=10.29 as=1.45 ps=10.29 w=10 l=10
X77 VGND blk07_0/n07_1 VGND VGND sky130_fd_pr__nfet_01v8 ad=1.45 pd=10.29 as=1.45 ps=10.29 w=10 l=10
X78 VGND blk07_0/n07_1 VGND VGND sky130_fd_pr__nfet_01v8 ad=0 pd=0 as=0 ps=0 w=10 l=10
X79 VGND blk07_0/n07_1 VGND VGND sky130_fd_pr__nfet_01v8 ad=0 pd=0 as=0 ps=0 w=10 l=10
X80 VGND blk07_0/n07_1 VGND VGND sky130_fd_pr__nfet_01v8 ad=0 pd=0 as=0 ps=0 w=10 l=10
X81 VGND blk07_0/n07_1 VGND VGND sky130_fd_pr__nfet_01v8 ad=0 pd=0 as=0 ps=0 w=10 l=10
X82 VGND blk07_0/n07_1 VGND VGND sky130_fd_pr__nfet_01v8 ad=0 pd=0 as=0 ps=0 w=10 l=10
X83 VGND blk07_0/n07_1 VGND VGND sky130_fd_pr__nfet_01v8 ad=0 pd=0 as=0 ps=0 w=10 l=10
X84 VGND blk07_0/n07_1 VGND VGND sky130_fd_pr__nfet_01v8 ad=0 pd=0 as=0 ps=0 w=10 l=10
X85 VGND blk07_0/n07_1 VGND VGND sky130_fd_pr__nfet_01v8 ad=0 pd=0 as=0 ps=0 w=10 l=10
X86 VGND blk07_0/n07_1 VGND VGND sky130_fd_pr__nfet_01v8 ad=0 pd=0 as=0 ps=0 w=10 l=10
X87 VGND blk07_0/n07_1 VGND VGND sky130_fd_pr__nfet_01v8 ad=0 pd=0 as=0 ps=0 w=10 l=10
X88 VGND blk07_0/n07_1 VGND VGND sky130_fd_pr__nfet_01v8 ad=0 pd=0 as=0 ps=0 w=10 l=10
X89 VGND blk07_0/n07_1 VGND VGND sky130_fd_pr__nfet_01v8 ad=0 pd=0 as=0 ps=0 w=10 l=10
X90 VGND blk07_0/n07_1 VGND VGND sky130_fd_pr__nfet_01v8 ad=0 pd=0 as=0 ps=0 w=10 l=10
X91 VGND blk07_0/n07_1 VGND VGND sky130_fd_pr__nfet_01v8 ad=0 pd=0 as=0 ps=0 w=10 l=10
X92 VGND blk07_0/n07_1 VGND VGND sky130_fd_pr__nfet_01v8 ad=0 pd=0 as=0 ps=0 w=10 l=10
X93 VGND blk07_0/n07_1 VGND VGND sky130_fd_pr__nfet_01v8 ad=0 pd=0 as=0 ps=0 w=10 l=10
X94 VGND blk07_0/n07_1 VGND VGND sky130_fd_pr__nfet_01v8 ad=0 pd=0 as=0 ps=0 w=10 l=10
X95 VGND blk07_0/n07_1 VGND VGND sky130_fd_pr__nfet_01v8 ad=0 pd=0 as=0 ps=0 w=10 l=10
X96 VGND blk07_0/n07_1 VGND VGND sky130_fd_pr__nfet_01v8 ad=0 pd=0 as=0 ps=0 w=10 l=10
X97 VGND blk07_0/n07_1 VGND VGND sky130_fd_pr__nfet_01v8 ad=0 pd=0 as=0 ps=0 w=10 l=10
X98 VGND blk07_0/n07_1 VGND VGND sky130_fd_pr__nfet_01v8 ad=0 pd=0 as=0 ps=0 w=10 l=10
X99 VGND blk07_0/n07_1 VGND VGND sky130_fd_pr__nfet_01v8 ad=0 pd=0 as=0 ps=0 w=10 l=10
X100 VGND blk07_0/n07_1 VGND VGND sky130_fd_pr__nfet_01v8 ad=0 pd=0 as=0 ps=0 w=10 l=10
X101 VGND blk07_0/n07_1 VGND VGND sky130_fd_pr__nfet_01v8 ad=0 pd=0 as=0 ps=0 w=10 l=10
X102 VGND blk07_0/n07_1 VGND VGND sky130_fd_pr__nfet_01v8 ad=0 pd=0 as=0 ps=0 w=10 l=10
X103 VGND blk07_0/n07_1 VGND VGND sky130_fd_pr__nfet_01v8 ad=0 pd=0 as=0 ps=0 w=10 l=10
X104 VGND blk07_0/n07_1 VGND VGND sky130_fd_pr__nfet_01v8 ad=0 pd=0 as=0 ps=0 w=10 l=10
X105 VGND blk07_0/n07_1 VGND VGND sky130_fd_pr__nfet_01v8 ad=0 pd=0 as=0 ps=0 w=10 l=10
X106 VGND blk07_0/n07_1 VGND VGND sky130_fd_pr__nfet_01v8 ad=0 pd=0 as=0 ps=0 w=10 l=10
X107 VGND blk07_0/n07_1 VGND VGND sky130_fd_pr__nfet_01v8 ad=0 pd=0 as=0 ps=0 w=10 l=10
X108 VGND blk07_0/n07_1 VGND VGND sky130_fd_pr__nfet_01v8 ad=0 pd=0 as=0 ps=0 w=10 l=10
X109 VGND blk07_0/n07_1 VGND VGND sky130_fd_pr__nfet_01v8 ad=0 pd=0 as=0 ps=0 w=10 l=10
X110 VGND blk07_0/n07_1 VGND VGND sky130_fd_pr__nfet_01v8 ad=0 pd=0 as=0 ps=0 w=10 l=10
X111 VGND blk07_0/n07_1 VGND VGND sky130_fd_pr__nfet_01v8 ad=0 pd=0 as=0 ps=0 w=10 l=10
X112 VGND blk07_0/n07_1 VGND VGND sky130_fd_pr__nfet_01v8 ad=0 pd=0 as=0 ps=0 w=10 l=10
X113 VGND blk07_0/n07_1 VGND VGND sky130_fd_pr__nfet_01v8 ad=0 pd=0 as=0 ps=0 w=10 l=10
X114 VGND blk07_0/n07_1 VGND VGND sky130_fd_pr__nfet_01v8 ad=0 pd=0 as=0 ps=0 w=10 l=10
X115 VGND blk07_0/n07_1 VGND VGND sky130_fd_pr__nfet_01v8 ad=0 pd=0 as=0 ps=0 w=10 l=10
X116 VGND blk07_0/n07_1 VGND VGND sky130_fd_pr__nfet_01v8 ad=0 pd=0 as=0 ps=0 w=10 l=10
X117 VGND blk07_0/n07_1 VGND VGND sky130_fd_pr__nfet_01v8 ad=0 pd=0 as=0 ps=0 w=10 l=10
X118 VGND blk07_0/n07_1 VGND VGND sky130_fd_pr__nfet_01v8 ad=0 pd=0 as=0 ps=0 w=10 l=10
X119 VGND blk07_0/n07_1 VGND VGND sky130_fd_pr__nfet_01v8 ad=0 pd=0 as=0 ps=0 w=10 l=10
X120 VGND blk07_0/n07_1 VGND VGND sky130_fd_pr__nfet_01v8 ad=0 pd=0 as=0 ps=0 w=10 l=10
X121 VGND blk07_0/n07_1 VGND VGND sky130_fd_pr__nfet_01v8 ad=0 pd=0 as=0 ps=0 w=10 l=10
X122 VGND blk07_0/n07_1 VGND VGND sky130_fd_pr__nfet_01v8 ad=0 pd=0 as=0 ps=0 w=10 l=10
X123 VGND blk07_0/n07_1 VGND VGND sky130_fd_pr__nfet_01v8 ad=0 pd=0 as=0 ps=0 w=10 l=10
X124 VGND blk07_0/n07_1 VGND VGND sky130_fd_pr__nfet_01v8 ad=0 pd=0 as=0 ps=0 w=10 l=10
X125 VGND blk07_0/n07_1 VGND VGND sky130_fd_pr__nfet_01v8 ad=0 pd=0 as=0 ps=0 w=10 l=10
X126 VGND blk07_0/n07_1 VGND VGND sky130_fd_pr__nfet_01v8 ad=0 pd=0 as=0 ps=0 w=10 l=10
X127 VGND blk07_0/n07_1 VGND VGND sky130_fd_pr__nfet_01v8 ad=0 pd=0 as=0 ps=0 w=10 l=10
X128 VGND blk07_0/n07_1 VGND VGND sky130_fd_pr__nfet_01v8 ad=0 pd=0 as=0 ps=0 w=10 l=10
X129 VGND blk07_0/n07_1 VGND VGND sky130_fd_pr__nfet_01v8 ad=0 pd=0 as=0 ps=0 w=10 l=10
X130 VGND blk07_0/n07_1 VGND VGND sky130_fd_pr__nfet_01v8 ad=0 pd=0 as=0 ps=0 w=10 l=10
X131 VGND blk07_0/n07_1 VGND VGND sky130_fd_pr__nfet_01v8 ad=0 pd=0 as=0 ps=0 w=10 l=10
X132 VGND blk07_0/n07_1 VGND VGND sky130_fd_pr__nfet_01v8 ad=0 pd=0 as=0 ps=0 w=10 l=10
X133 VGND blk07_0/n07_1 VGND VGND sky130_fd_pr__nfet_01v8 ad=0 pd=0 as=0 ps=0 w=10 l=10
X134 VGND blk07_0/n07_1 VGND VGND sky130_fd_pr__nfet_01v8 ad=0 pd=0 as=0 ps=0 w=10 l=10
X135 VGND blk07_0/n07_1 VGND VGND sky130_fd_pr__nfet_01v8 ad=0 pd=0 as=0 ps=0 w=10 l=10
X136 VGND blk07_0/n07_1 VGND VGND sky130_fd_pr__nfet_01v8 ad=0 pd=0 as=0 ps=0 w=10 l=10
X137 VGND blk07_0/n07_1 VGND VGND sky130_fd_pr__nfet_01v8 ad=0 pd=0 as=0 ps=0 w=10 l=10
X138 VGND blk07_0/n07_1 VGND VGND sky130_fd_pr__nfet_01v8 ad=0 pd=0 as=0 ps=0 w=10 l=10
X139 VGND blk07_0/n07_1 VGND VGND sky130_fd_pr__nfet_01v8 ad=0 pd=0 as=0 ps=0 w=10 l=10
X140 VGND blk07_0/n07_1 VGND VGND sky130_fd_pr__nfet_01v8 ad=0 pd=0 as=0 ps=0 w=10 l=10
X141 VGND blk07_0/n07_1 VGND VGND sky130_fd_pr__nfet_01v8 ad=0 pd=0 as=0 ps=0 w=10 l=10
X142 VGND blk07_0/n07_1 VGND VGND sky130_fd_pr__nfet_01v8 ad=0 pd=0 as=0 ps=0 w=10 l=10
X143 VGND blk07_0/n07_1 VGND VGND sky130_fd_pr__nfet_01v8 ad=0 pd=0 as=0 ps=0 w=10 l=10
X144 VGND blk07_0/n07_1 VGND VGND sky130_fd_pr__nfet_01v8 ad=0 pd=0 as=0 ps=0 w=10 l=10
X145 VGND blk07_0/n07_1 VGND VGND sky130_fd_pr__nfet_01v8 ad=0 pd=0 as=0 ps=0 w=10 l=10
X146 VGND blk07_0/n07_1 VGND VGND sky130_fd_pr__nfet_01v8 ad=0 pd=0 as=0 ps=0 w=10 l=10
X147 VGND blk07_0/n07_1 VGND VGND sky130_fd_pr__nfet_01v8 ad=0 pd=0 as=0 ps=0 w=10 l=10
X148 VGND blk07_0/n07_1 VGND VGND sky130_fd_pr__nfet_01v8 ad=0 pd=0 as=0 ps=0 w=10 l=10
X149 VGND blk07_0/n07_1 VGND VGND sky130_fd_pr__nfet_01v8 ad=0 pd=0 as=0 ps=0 w=10 l=10
X150 VGND blk07_0/n07_1 VGND VGND sky130_fd_pr__nfet_01v8 ad=0 pd=0 as=0 ps=0 w=10 l=10
X151 VGND blk07_0/n07_1 VGND VGND sky130_fd_pr__nfet_01v8 ad=0 pd=0 as=0 ps=0 w=10 l=10
X152 VGND blk07_0/n07_1 VGND VGND sky130_fd_pr__nfet_01v8 ad=0 pd=0 as=0 ps=0 w=10 l=10
X153 VGND blk07_0/n07_1 VGND VGND sky130_fd_pr__nfet_01v8 ad=0 pd=0 as=0 ps=0 w=10 l=10
X154 VGND blk07_0/n07_1 VGND VGND sky130_fd_pr__nfet_01v8 ad=0 pd=0 as=0 ps=0 w=10 l=10
X155 VGND blk07_0/n07_1 VGND VGND sky130_fd_pr__nfet_01v8 ad=0 pd=0 as=0 ps=0 w=10 l=10
X156 VGND blk07_0/n07_1 VGND VGND sky130_fd_pr__nfet_01v8 ad=0 pd=0 as=0 ps=0 w=10 l=10
X157 VGND blk07_0/n07_1 VGND VGND sky130_fd_pr__nfet_01v8 ad=0 pd=0 as=0 ps=0 w=10 l=10
X158 VGND blk07_0/n07_1 VGND VGND sky130_fd_pr__nfet_01v8 ad=0 pd=0 as=0 ps=0 w=10 l=10
X159 VGND blk07_0/n07_1 VGND VGND sky130_fd_pr__nfet_01v8 ad=0 pd=0 as=0 ps=0 w=10 l=10
X160 VGND blk07_0/n07_1 VGND VGND sky130_fd_pr__nfet_01v8 ad=0 pd=0 as=0 ps=0 w=10 l=10
X161 VGND blk07_0/n07_1 VGND VGND sky130_fd_pr__nfet_01v8 ad=0 pd=0 as=0 ps=0 w=10 l=10
X162 VGND blk07_0/n07_2 VGND VGND sky130_fd_pr__nfet_01v8 ad=0 pd=0 as=0 ps=0 w=10 l=10
X163 VGND blk07_0/n07_2 VGND VGND sky130_fd_pr__nfet_01v8 ad=0 pd=0 as=0 ps=0 w=10 l=10
X164 VGND blk07_0/n07_2 VGND VGND sky130_fd_pr__nfet_01v8 ad=0 pd=0 as=0 ps=0 w=10 l=10
X165 VGND blk07_0/n07_2 VGND VGND sky130_fd_pr__nfet_01v8 ad=0 pd=0 as=0 ps=0 w=10 l=10
X166 VGND blk07_0/n07_2 VGND VGND sky130_fd_pr__nfet_01v8 ad=0 pd=0 as=0 ps=0 w=10 l=10
X167 VGND blk07_0/n07_2 VGND VGND sky130_fd_pr__nfet_01v8 ad=0 pd=0 as=0 ps=0 w=10 l=10
X168 VGND blk07_0/n07_2 VGND VGND sky130_fd_pr__nfet_01v8 ad=0 pd=0 as=0 ps=0 w=10 l=10
X169 VGND blk07_0/n07_2 VGND VGND sky130_fd_pr__nfet_01v8 ad=0 pd=0 as=0 ps=0 w=10 l=10
X170 VGND blk07_0/n07_2 VGND VGND sky130_fd_pr__nfet_01v8 ad=0 pd=0 as=0 ps=0 w=10 l=10
X171 VGND blk07_0/n07_2 VGND VGND sky130_fd_pr__nfet_01v8 ad=0 pd=0 as=0 ps=0 w=10 l=10
X172 VGND blk07_0/n07_2 VGND VGND sky130_fd_pr__nfet_01v8 ad=0 pd=0 as=0 ps=0 w=10 l=10
X173 VGND blk07_0/n07_2 VGND VGND sky130_fd_pr__nfet_01v8 ad=0 pd=0 as=0 ps=0 w=10 l=10
X174 VGND blk07_0/n07_2 VGND VGND sky130_fd_pr__nfet_01v8 ad=0 pd=0 as=0 ps=0 w=10 l=10
X175 VGND blk07_0/n07_2 VGND VGND sky130_fd_pr__nfet_01v8 ad=0 pd=0 as=0 ps=0 w=10 l=10
X176 VGND blk07_0/n07_2 VGND VGND sky130_fd_pr__nfet_01v8 ad=0 pd=0 as=0 ps=0 w=10 l=10
X177 VGND blk07_0/n07_2 VGND VGND sky130_fd_pr__nfet_01v8 ad=0 pd=0 as=0 ps=0 w=10 l=10
X178 VGND blk07_0/n07_2 VGND VGND sky130_fd_pr__nfet_01v8 ad=0 pd=0 as=0 ps=0 w=10 l=10
X179 VGND blk07_0/n07_2 VGND VGND sky130_fd_pr__nfet_01v8 ad=0 pd=0 as=0 ps=0 w=10 l=10
X180 VGND blk07_0/n07_2 VGND VGND sky130_fd_pr__nfet_01v8 ad=0 pd=0 as=0 ps=0 w=10 l=10
X181 VGND blk07_0/n07_2 VGND VGND sky130_fd_pr__nfet_01v8 ad=0 pd=0 as=0 ps=0 w=10 l=10
X182 VGND blk07_0/n07_2 VGND VGND sky130_fd_pr__nfet_01v8 ad=0 pd=0 as=0 ps=0 w=10 l=10
X183 VGND blk07_0/n07_2 VGND VGND sky130_fd_pr__nfet_01v8 ad=0 pd=0 as=0 ps=0 w=10 l=10
X184 VGND blk07_0/n07_2 VGND VGND sky130_fd_pr__nfet_01v8 ad=0 pd=0 as=0 ps=0 w=10 l=10
X185 VGND blk07_0/n07_2 VGND VGND sky130_fd_pr__nfet_01v8 ad=0 pd=0 as=0 ps=0 w=10 l=10
X186 VGND blk07_0/n07_2 VGND VGND sky130_fd_pr__nfet_01v8 ad=0 pd=0 as=0 ps=0 w=10 l=10
X187 VGND blk07_0/n07_2 VGND VGND sky130_fd_pr__nfet_01v8 ad=0 pd=0 as=0 ps=0 w=10 l=10
X188 VGND blk07_0/n07_2 VGND VGND sky130_fd_pr__nfet_01v8 ad=0 pd=0 as=0 ps=0 w=10 l=10
X189 VGND blk07_0/n07_2 VGND VGND sky130_fd_pr__nfet_01v8 ad=0 pd=0 as=0 ps=0 w=10 l=10
X190 VGND blk07_0/n07_2 VGND VGND sky130_fd_pr__nfet_01v8 ad=0 pd=0 as=0 ps=0 w=10 l=10
X191 VGND blk07_0/n07_2 VGND VGND sky130_fd_pr__nfet_01v8 ad=0 pd=0 as=0 ps=0 w=10 l=10
X192 VGND blk07_0/n07_2 VGND VGND sky130_fd_pr__nfet_01v8 ad=0 pd=0 as=0 ps=0 w=10 l=10
X193 VGND blk07_0/n07_2 VGND VGND sky130_fd_pr__nfet_01v8 ad=0 pd=0 as=0 ps=0 w=10 l=10
X194 VGND blk07_0/n07_2 VGND VGND sky130_fd_pr__nfet_01v8 ad=0 pd=0 as=0 ps=0 w=10 l=10
X195 VGND blk07_0/n07_2 VGND VGND sky130_fd_pr__nfet_01v8 ad=0 pd=0 as=0 ps=0 w=10 l=10
X196 VGND blk07_0/n07_2 VGND VGND sky130_fd_pr__nfet_01v8 ad=0 pd=0 as=0 ps=0 w=10 l=10
X197 VGND blk07_0/n07_2 VGND VGND sky130_fd_pr__nfet_01v8 ad=0 pd=0 as=0 ps=0 w=10 l=10
X198 VGND blk07_0/n07_2 VGND VGND sky130_fd_pr__nfet_01v8 ad=1.45 pd=10.29 as=2.9 ps=20.58 w=10 l=10
X199 VGND blk07_0/n07_2 VGND VGND sky130_fd_pr__nfet_01v8 ad=1.45 pd=10.29 as=1.45 ps=10.29 w=10 l=10
X200 VGND blk07_0/n07_2 VGND VGND sky130_fd_pr__nfet_01v8 ad=1.45 pd=10.29 as=1.45 ps=10.29 w=10 l=10
X201 VGND blk07_0/n07_2 VGND VGND sky130_fd_pr__nfet_01v8 ad=2.9 pd=20.58 as=1.45 ps=10.29 w=10 l=10
X202 VGND blk07_0/n07_2 VGND VGND sky130_fd_pr__nfet_01v8 ad=1.45 pd=10.29 as=1.45 ps=10.29 w=10 l=10
X203 VGND blk07_0/n07_2 VGND VGND sky130_fd_pr__nfet_01v8 ad=1.45 pd=10.29 as=1.45 ps=10.29 w=10 l=10
X204 VGND blk07_0/n07_2 VGND VGND sky130_fd_pr__nfet_01v8 ad=1.45 pd=10.29 as=1.45 ps=10.29 w=10 l=10
X205 VGND blk07_0/n07_2 VGND VGND sky130_fd_pr__nfet_01v8 ad=1.45 pd=10.29 as=1.45 ps=10.29 w=10 l=10
X206 VGND blk07_0/n07_2 VGND VGND sky130_fd_pr__nfet_01v8 ad=1.45 pd=10.29 as=1.45 ps=10.29 w=10 l=10
X207 VGND blk07_0/n07_2 VGND VGND sky130_fd_pr__nfet_01v8 ad=1.45 pd=10.29 as=1.45 ps=10.29 w=10 l=10
X208 VGND blk07_0/n07_3 VGND VGND sky130_fd_pr__nfet_01v8 ad=0 pd=0 as=0 ps=0 w=10 l=10
X209 VGND blk07_0/n07_3 VGND VGND sky130_fd_pr__nfet_01v8 ad=0 pd=0 as=0 ps=0 w=10 l=10
X210 VGND blk07_0/n07_3 VGND VGND sky130_fd_pr__nfet_01v8 ad=0 pd=0 as=0 ps=0 w=10 l=10
X211 VGND blk07_0/n07_3 VGND VGND sky130_fd_pr__nfet_01v8 ad=0 pd=0 as=0 ps=0 w=10 l=10
X212 VGND blk07_0/n07_3 VGND VGND sky130_fd_pr__nfet_01v8 ad=0 pd=0 as=0 ps=0 w=10 l=10
X213 VGND blk07_0/n07_3 VGND VGND sky130_fd_pr__nfet_01v8 ad=0 pd=0 as=0 ps=0 w=10 l=10
X214 VGND blk07_0/n07_3 VGND VGND sky130_fd_pr__nfet_01v8 ad=0 pd=0 as=0 ps=0 w=10 l=10
X215 VGND blk07_0/n07_3 VGND VGND sky130_fd_pr__nfet_01v8 ad=0 pd=0 as=0 ps=0 w=10 l=10
X216 VGND blk07_0/n07_3 VGND VGND sky130_fd_pr__nfet_01v8 ad=0 pd=0 as=0 ps=0 w=10 l=10
X217 VGND blk07_0/n07_3 VGND VGND sky130_fd_pr__nfet_01v8 ad=0 pd=0 as=0 ps=0 w=10 l=10
X218 VGND blk07_0/n07_3 VGND VGND sky130_fd_pr__nfet_01v8 ad=0 pd=0 as=0 ps=0 w=10 l=10
X219 VGND blk07_0/n07_3 VGND VGND sky130_fd_pr__nfet_01v8 ad=0 pd=0 as=0 ps=0 w=10 l=10
X220 VGND blk07_0/n07_3 VGND VGND sky130_fd_pr__nfet_01v8 ad=0 pd=0 as=0 ps=0 w=10 l=10
X221 VGND blk07_0/n07_3 VGND VGND sky130_fd_pr__nfet_01v8 ad=0 pd=0 as=0 ps=0 w=10 l=10
X222 VGND blk07_0/n07_3 VGND VGND sky130_fd_pr__nfet_01v8 ad=0 pd=0 as=0 ps=0 w=10 l=10
X223 VGND blk07_0/n07_3 VGND VGND sky130_fd_pr__nfet_01v8 ad=0 pd=0 as=0 ps=0 w=10 l=10
X224 VGND blk07_0/n07_3 VGND VGND sky130_fd_pr__nfet_01v8 ad=0 pd=0 as=0 ps=0 w=10 l=10
X225 VGND blk07_0/n07_3 VGND VGND sky130_fd_pr__nfet_01v8 ad=0 pd=0 as=0 ps=0 w=10 l=10
X226 VGND blk07_0/n07_3 VGND VGND sky130_fd_pr__nfet_01v8 ad=0 pd=0 as=0 ps=0 w=10 l=10
X227 VGND blk07_0/n07_3 VGND VGND sky130_fd_pr__nfet_01v8 ad=0 pd=0 as=0 ps=0 w=10 l=10
X228 VGND blk07_0/n07_3 VGND VGND sky130_fd_pr__nfet_01v8 ad=0 pd=0 as=0 ps=0 w=10 l=10
X229 VGND blk07_0/n07_3 VGND VGND sky130_fd_pr__nfet_01v8 ad=0 pd=0 as=0 ps=0 w=10 l=10
X230 VGND blk07_0/n07_3 VGND VGND sky130_fd_pr__nfet_01v8 ad=0 pd=0 as=0 ps=0 w=10 l=10
X231 VGND blk07_0/n07_3 VGND VGND sky130_fd_pr__nfet_01v8 ad=0 pd=0 as=0 ps=0 w=10 l=10
X232 blk07_0/n07_3 VGND sky130_fd_pr__cap_mim_m3_1 l=20.31 w=29.96
X233 ua[0] swA4/S7 sky130_fd_pr__cap_mim_m3_1 l=19.86 w=29.8
X234 ua[0] swA4/S7 sky130_fd_pr__cap_mim_m3_1 l=19.86 w=29.8
X235 blk07_0/n07_5 VGND sky130_fd_pr__cap_mim_m3_1 l=9.86 w=29.96
X236 blk07_0/n07_4 VGND sky130_fd_pr__cap_mim_m3_1 l=11.71 w=29.96
X237 ua[0] swA3/S3 sky130_fd_pr__cap_mim_m3_1 l=19.86 w=29.8
X238 blk07_0/n07_2 VGND sky130_fd_pr__cap_mim_m3_1 l=15.39 w=29.96
X239 blk07_0/n07_1 VGND sky130_fd_pr__cap_mim_m3_1 l=25.02 w=29.96
X240 blk07_0/n07_2 VGND sky130_fd_pr__cap_mim_m3_1 l=15.39 w=29.96
X241 blk07_0/n07_1 VGND sky130_fd_pr__cap_mim_m3_1 l=25.02 w=29.96
X242 blk07_0/n07_1 VGND sky130_fd_pr__cap_mim_m3_1 l=25.02 w=29.96
X243 ua[0] swA4/S7 sky130_fd_pr__cap_mim_m3_1 l=19.86 w=29.8
X244 blk07_0/n07_1 VGND sky130_fd_pr__cap_mim_m3_1 l=25.02 w=29.96
X245 blk07_0/n07_1 VGND sky130_fd_pr__cap_mim_m3_1 l=25.02 w=29.96
X246 blk07_0/n07_5 VGND sky130_fd_pr__cap_mim_m3_1 l=9.86 w=29.96
X247 blk07_0/n07_4 VGND sky130_fd_pr__cap_mim_m3_1 l=11.71 w=29.96
X248 blk07_0/n07_3 VGND sky130_fd_pr__cap_mim_m3_1 l=20.31 w=29.96
X249 blk07_0/n07_2 VGND sky130_fd_pr__cap_mim_m3_1 l=15.39 w=29.96
X250 blk07_0/n07_2 VGND sky130_fd_pr__cap_mim_m3_1 l=15.39 w=29.96
X251 blk07_0/n07_1 VGND sky130_fd_pr__cap_mim_m3_1 l=25.02 w=29.96
X252 blk07_0/n07_3 VGND sky130_fd_pr__cap_mim_m3_1 l=20.31 w=29.96
X253 ua[0] swA4/S7 sky130_fd_pr__cap_mim_m3_1 l=19.86 w=29.8
X254 blk07_0/n07_5 VGND sky130_fd_pr__cap_mim_m3_1 l=9.86 w=29.96
X255 blk07_0/n07_4 VGND sky130_fd_pr__cap_mim_m3_1 l=11.71 w=29.96
X256 blk07_0/n07_2 VGND sky130_fd_pr__cap_mim_m3_1 l=15.39 w=29.96
X257 ua[0] swA3/S3 sky130_fd_pr__cap_mim_m3_1 l=19.86 w=29.8
X258 blk07_0/n07_5 VGND sky130_fd_pr__cap_mim_m3_1 l=9.86 w=29.96
X259 blk07_0/n07_2 VGND sky130_fd_pr__cap_mim_m3_1 l=15.39 w=29.96
X260 blk07_0/n07_1 VGND sky130_fd_pr__cap_mim_m3_1 l=25.02 w=29.96
X261 blk07_0/n07_4 VGND sky130_fd_pr__cap_mim_m3_1 l=11.71 w=29.96
X262 blk07_0/n07_2 VGND sky130_fd_pr__cap_mim_m3_1 l=15.39 w=29.96
X263 blk07_0/n07_2 VGND sky130_fd_pr__cap_mim_m3_1 l=15.39 w=29.96
X264 ua[0] swA2/S1 sky130_fd_pr__cap_mim_m3_1 l=19.86 w=29.8
X265 ua[0] swA0/S1 sky130_fd_pr__cap_mim_m3_1 l=19.86 w=7.33
X266 blk07_0/n07_1 VGND sky130_fd_pr__cap_mim_m3_1 l=25.02 w=29.96
X267 blk07_0/n07_1 VGND sky130_fd_pr__cap_mim_m3_1 l=25.02 w=29.96
X268 blk07_0/n07_3 VGND sky130_fd_pr__cap_mim_m3_1 l=20.31 w=29.96
X269 blk07_0/n07_1 VGND sky130_fd_pr__cap_mim_m3_1 l=25.02 w=29.96
X270 ua[0] swA1/S1 sky130_fd_pr__cap_mim_m3_1 l=19.86 w=14.82
X271 blk07_0/n07_1 VGND sky130_fd_pr__cap_mim_m3_1 l=25.02 w=29.96
X272 blk07_0/n07_1 VGND sky130_fd_pr__cap_mim_m3_1 l=25.02 w=29.96
X273 VDPWR sky130_fd_sc_hd__buf_2_3/a_27_47# swB1/G VDPWR sky130_fd_pr__pfet_01v8_hvt ad=0 pd=0 as=0.27 ps=2.54 w=1 l=0.15
X274 swB1/G sky130_fd_sc_hd__buf_2_3/a_27_47# VDPWR VDPWR sky130_fd_pr__pfet_01v8_hvt ad=0 pd=0 as=0 ps=0 w=1 l=0.15
X275 VDPWR uio_in[1] sky130_fd_sc_hd__buf_2_3/a_27_47# VDPWR sky130_fd_pr__pfet_01v8_hvt ad=0 pd=0 as=0.1664 ps=1.8 w=0.64 l=0.15
X276 swB1/G sky130_fd_sc_hd__buf_2_3/a_27_47# VGND VGND sky130_fd_pr__nfet_01v8 ad=0.1755 pd=1.84 as=0 ps=0 w=0.65 l=0.15
X277 VGND sky130_fd_sc_hd__buf_2_3/a_27_47# swB1/G VGND sky130_fd_pr__nfet_01v8 ad=0 pd=0 as=0 ps=0 w=0.65 l=0.15
X278 VGND uio_in[1] sky130_fd_sc_hd__buf_2_3/a_27_47# VGND sky130_fd_pr__nfet_01v8 ad=0 pd=0 as=0.1092 ps=1.36 w=0.42 l=0.15
X279 VDPWR sky130_fd_sc_hd__buf_2_4/a_27_47# swB0/G VDPWR sky130_fd_pr__pfet_01v8_hvt ad=0 pd=0 as=0.27 ps=2.54 w=1 l=0.15
X280 swB0/G sky130_fd_sc_hd__buf_2_4/a_27_47# VDPWR VDPWR sky130_fd_pr__pfet_01v8_hvt ad=0 pd=0 as=0 ps=0 w=1 l=0.15
X281 VDPWR uio_in[0] sky130_fd_sc_hd__buf_2_4/a_27_47# VDPWR sky130_fd_pr__pfet_01v8_hvt ad=0 pd=0 as=0.1664 ps=1.8 w=0.64 l=0.15
X282 swB0/G sky130_fd_sc_hd__buf_2_4/a_27_47# VGND VGND sky130_fd_pr__nfet_01v8 ad=0.1755 pd=1.84 as=0 ps=0 w=0.65 l=0.15
X283 VGND sky130_fd_sc_hd__buf_2_4/a_27_47# swB0/G VGND sky130_fd_pr__nfet_01v8 ad=0 pd=0 as=0 ps=0 w=0.65 l=0.15
X284 VGND uio_in[0] sky130_fd_sc_hd__buf_2_4/a_27_47# VGND sky130_fd_pr__nfet_01v8 ad=0 pd=0 as=0.1092 ps=1.36 w=0.42 l=0.15
X285 VDPWR sky130_fd_sc_hd__conb_1_20/HI sky130_fd_pr__res_generic_po w=0.48 l=0.5
X286 uo_out[3] VGND sky130_fd_pr__res_generic_po w=0.48 l=0.5
X287 VDPWR sky130_fd_sc_hd__buf_2_5/a_27_47# swA4/G VDPWR sky130_fd_pr__pfet_01v8_hvt ad=0 pd=0 as=0.27 ps=2.54 w=1 l=0.15
X288 swA4/G sky130_fd_sc_hd__buf_2_5/a_27_47# VDPWR VDPWR sky130_fd_pr__pfet_01v8_hvt ad=0 pd=0 as=0 ps=0 w=1 l=0.15
X289 VDPWR ui_in[4] sky130_fd_sc_hd__buf_2_5/a_27_47# VDPWR sky130_fd_pr__pfet_01v8_hvt ad=0 pd=0 as=0.1664 ps=1.8 w=0.64 l=0.15
X290 swA4/G sky130_fd_sc_hd__buf_2_5/a_27_47# VGND VGND sky130_fd_pr__nfet_01v8 ad=0.1755 pd=1.84 as=0 ps=0 w=0.65 l=0.15
X291 VGND sky130_fd_sc_hd__buf_2_5/a_27_47# swA4/G VGND sky130_fd_pr__nfet_01v8 ad=0 pd=0 as=0 ps=0 w=0.65 l=0.15
X292 VGND ui_in[4] sky130_fd_sc_hd__buf_2_5/a_27_47# VGND sky130_fd_pr__nfet_01v8 ad=0 pd=0 as=0.1092 ps=1.36 w=0.42 l=0.15
X293 VGND blk05_0/n05_1 VGND VGND sky130_fd_pr__nfet_01v8 ad=0 pd=0 as=0 ps=0 w=10 l=10
X294 VGND blk05_0/n05_1 VGND VGND sky130_fd_pr__nfet_01v8 ad=0 pd=0 as=0 ps=0 w=10 l=10
X295 VGND blk05_0/n05_1 VGND VGND sky130_fd_pr__nfet_01v8 ad=0 pd=0 as=0 ps=0 w=10 l=10
X296 VGND blk05_0/n05_1 VGND VGND sky130_fd_pr__nfet_01v8 ad=0 pd=0 as=0 ps=0 w=10 l=10
X297 VGND blk05_0/n05_1 VGND VGND sky130_fd_pr__nfet_01v8 ad=0 pd=0 as=0 ps=0 w=10 l=10
X298 VGND blk05_0/n05_1 VGND VGND sky130_fd_pr__nfet_01v8 ad=0 pd=0 as=0 ps=0 w=10 l=10
X299 VGND blk05_0/n05_1 VGND VGND sky130_fd_pr__nfet_01v8 ad=0 pd=0 as=0 ps=0 w=10 l=10
X300 VGND blk05_0/n05_1 VGND VGND sky130_fd_pr__nfet_01v8 ad=0 pd=0 as=0 ps=0 w=10 l=10
X301 VGND blk05_0/n05_1 VGND VGND sky130_fd_pr__nfet_01v8 ad=0 pd=0 as=0 ps=0 w=10 l=10
X302 VGND blk05_0/n05_1 VGND VGND sky130_fd_pr__nfet_01v8 ad=0 pd=0 as=0 ps=0 w=10 l=10
X303 VGND blk05_0/n05_1 VGND VGND sky130_fd_pr__nfet_01v8 ad=0 pd=0 as=0 ps=0 w=10 l=10
X304 VGND blk05_0/n05_1 VGND VGND sky130_fd_pr__nfet_01v8 ad=0 pd=0 as=0 ps=0 w=10 l=10
X305 VGND blk05_0/n05_1 VGND VGND sky130_fd_pr__nfet_01v8 ad=0 pd=0 as=0 ps=0 w=10 l=10
X306 VGND blk05_0/n05_1 VGND VGND sky130_fd_pr__nfet_01v8 ad=0 pd=0 as=0 ps=0 w=10 l=10
X307 VGND blk05_0/n05_1 VGND VGND sky130_fd_pr__nfet_01v8 ad=0 pd=0 as=0 ps=0 w=10 l=10
X308 VGND blk05_0/n05_1 VGND VGND sky130_fd_pr__nfet_01v8 ad=0 pd=0 as=0 ps=0 w=10 l=10
X309 VGND blk05_0/n05_1 VGND VGND sky130_fd_pr__nfet_01v8 ad=0 pd=0 as=0 ps=0 w=10 l=10
X310 VGND blk05_0/n05_1 VGND VGND sky130_fd_pr__nfet_01v8 ad=0 pd=0 as=0 ps=0 w=10 l=10
X311 VGND blk05_0/n05_1 VGND VGND sky130_fd_pr__nfet_01v8 ad=0 pd=0 as=0 ps=0 w=10 l=10
X312 VGND blk05_0/n05_1 VGND VGND sky130_fd_pr__nfet_01v8 ad=0 pd=0 as=0 ps=0 w=10 l=10
X313 VGND blk05_0/n05_1 VGND VGND sky130_fd_pr__nfet_01v8 ad=0 pd=0 as=0 ps=0 w=10 l=10
X314 VGND blk05_0/n05_1 VGND VGND sky130_fd_pr__nfet_01v8 ad=0 pd=0 as=0 ps=0 w=10 l=10
X315 VGND blk05_0/n05_1 VGND VGND sky130_fd_pr__nfet_01v8 ad=0 pd=0 as=0 ps=0 w=10 l=10
X316 VGND blk05_0/n05_1 VGND VGND sky130_fd_pr__nfet_01v8 ad=0 pd=0 as=0 ps=0 w=10 l=10
X317 VGND blk05_0/n05_1 VGND VGND sky130_fd_pr__nfet_01v8 ad=2.9 pd=20.58 as=2.9 ps=20.58 w=10 l=10
X318 VGND blk05_0/n05_2 VGND VGND sky130_fd_pr__nfet_01v8 ad=0 pd=0 as=0 ps=0 w=10 l=10
X319 VGND blk05_0/n05_2 VGND VGND sky130_fd_pr__nfet_01v8 ad=0 pd=0 as=0 ps=0 w=10 l=10
X320 VGND blk05_0/n05_2 VGND VGND sky130_fd_pr__nfet_01v8 ad=0 pd=0 as=0 ps=0 w=10 l=10
X321 VGND blk05_0/n05_2 VGND VGND sky130_fd_pr__nfet_01v8 ad=0 pd=0 as=0 ps=0 w=10 l=10
X322 VGND blk05_0/n05_2 VGND VGND sky130_fd_pr__nfet_01v8 ad=0 pd=0 as=0 ps=0 w=10 l=10
X323 VGND blk05_0/n05_2 VGND VGND sky130_fd_pr__nfet_01v8 ad=0 pd=0 as=0 ps=0 w=10 l=10
X324 VGND blk05_0/n05_2 VGND VGND sky130_fd_pr__nfet_01v8 ad=0 pd=0 as=0 ps=0 w=10 l=10
X325 VGND blk05_0/n05_2 VGND VGND sky130_fd_pr__nfet_01v8 ad=0 pd=0 as=0 ps=0 w=10 l=10
X326 VGND blk05_0/n05_2 VGND VGND sky130_fd_pr__nfet_01v8 ad=0 pd=0 as=0 ps=0 w=10 l=10
X327 VGND blk05_0/n05_2 VGND VGND sky130_fd_pr__nfet_01v8 ad=0 pd=0 as=0 ps=0 w=10 l=10
X328 VGND blk05_0/n05_2 VGND VGND sky130_fd_pr__nfet_01v8 ad=0 pd=0 as=0 ps=0 w=10 l=10
X329 VGND blk05_0/n05_2 VGND VGND sky130_fd_pr__nfet_01v8 ad=0 pd=0 as=0 ps=0 w=10 l=10
X330 VGND blk05_0/n05_2 VGND VGND sky130_fd_pr__nfet_01v8 ad=0 pd=0 as=0 ps=0 w=10 l=10
X331 VGND blk05_0/n05_2 VGND VGND sky130_fd_pr__nfet_01v8 ad=0 pd=0 as=0 ps=0 w=10 l=10
X332 VGND blk05_0/n05_2 VGND VGND sky130_fd_pr__nfet_01v8 ad=0 pd=0 as=0 ps=0 w=10 l=10
X333 VGND blk05_0/n05_2 VGND VGND sky130_fd_pr__nfet_01v8 ad=0 pd=0 as=0 ps=0 w=10 l=10
X334 VGND blk05_0/n05_2 VGND VGND sky130_fd_pr__nfet_01v8 ad=0 pd=0 as=0 ps=0 w=10 l=10
X335 VGND blk05_0/n05_2 VGND VGND sky130_fd_pr__nfet_01v8 ad=0 pd=0 as=0 ps=0 w=10 l=10
X336 VGND blk05_0/n05_2 VGND VGND sky130_fd_pr__nfet_01v8 ad=0 pd=0 as=0 ps=0 w=10 l=10
X337 VGND blk05_0/n05_2 VGND VGND sky130_fd_pr__nfet_01v8 ad=0 pd=0 as=0 ps=0 w=10 l=10
X338 VGND blk05_0/n05_2 VGND VGND sky130_fd_pr__nfet_01v8 ad=0 pd=0 as=0 ps=0 w=10 l=10
X339 VGND blk05_0/n05_2 VGND VGND sky130_fd_pr__nfet_01v8 ad=0 pd=0 as=0 ps=0 w=10 l=10
X340 VGND blk05_0/n05_2 VGND VGND sky130_fd_pr__nfet_01v8 ad=0 pd=0 as=0 ps=0 w=10 l=10
X341 VGND blk05_0/n05_2 VGND VGND sky130_fd_pr__nfet_01v8 ad=0 pd=0 as=0 ps=0 w=10 l=10
X342 VGND blk05_0/n05_2 VGND VGND sky130_fd_pr__nfet_01v8 ad=0 pd=0 as=0 ps=0 w=10 l=10
X343 VGND blk05_0/n05_2 VGND VGND sky130_fd_pr__nfet_01v8 ad=0 pd=0 as=0 ps=0 w=10 l=10
X344 VGND blk05_0/n05_2 VGND VGND sky130_fd_pr__nfet_01v8 ad=0 pd=0 as=0 ps=0 w=10 l=10
X345 VGND blk05_0/n05_2 VGND VGND sky130_fd_pr__nfet_01v8 ad=0 pd=0 as=0 ps=0 w=10 l=10
X346 VGND blk05_0/n05_2 VGND VGND sky130_fd_pr__nfet_01v8 ad=0 pd=0 as=0 ps=0 w=10 l=10
X347 VGND blk05_0/n05_2 VGND VGND sky130_fd_pr__nfet_01v8 ad=0 pd=0 as=0 ps=0 w=10 l=10
X348 VGND blk05_0/n05_2 VGND VGND sky130_fd_pr__nfet_01v8 ad=0 pd=0 as=0 ps=0 w=10 l=10
X349 VGND blk05_0/n05_2 VGND VGND sky130_fd_pr__nfet_01v8 ad=0 pd=0 as=0 ps=0 w=10 l=10
X350 VGND blk05_0/n05_2 VGND VGND sky130_fd_pr__nfet_01v8 ad=0 pd=0 as=0 ps=0 w=10 l=10
X351 VGND blk05_0/n05_2 VGND VGND sky130_fd_pr__nfet_01v8 ad=0 pd=0 as=0 ps=0 w=10 l=10
X352 VGND blk05_0/n05_2 VGND VGND sky130_fd_pr__nfet_01v8 ad=0 pd=0 as=0 ps=0 w=10 l=10
X353 VGND blk05_0/n05_2 VGND VGND sky130_fd_pr__nfet_01v8 ad=0 pd=0 as=0 ps=0 w=10 l=10
X354 VGND blk05_0/n05_2 VGND VGND sky130_fd_pr__nfet_01v8 ad=0 pd=0 as=0 ps=0 w=10 l=10
X355 VGND blk05_0/n05_2 VGND VGND sky130_fd_pr__nfet_01v8 ad=0 pd=0 as=0 ps=0 w=10 l=10
X356 VGND blk05_0/n05_2 VGND VGND sky130_fd_pr__nfet_01v8 ad=0 pd=0 as=0 ps=0 w=10 l=10
X357 VGND blk05_0/n05_2 VGND VGND sky130_fd_pr__nfet_01v8 ad=0 pd=0 as=0 ps=0 w=10 l=10
X358 VGND blk05_0/n05_2 VGND VGND sky130_fd_pr__nfet_01v8 ad=0 pd=0 as=0 ps=0 w=10 l=10
X359 VGND blk05_0/n05_2 VGND VGND sky130_fd_pr__nfet_01v8 ad=0 pd=0 as=0 ps=0 w=10 l=10
X360 VGND blk05_0/n05_2 VGND VGND sky130_fd_pr__nfet_01v8 ad=0 pd=0 as=0 ps=0 w=10 l=10
X361 VGND blk05_0/n05_2 VGND VGND sky130_fd_pr__nfet_01v8 ad=0 pd=0 as=0 ps=0 w=10 l=10
X362 VGND blk05_0/n05_2 VGND VGND sky130_fd_pr__nfet_01v8 ad=0 pd=0 as=0 ps=0 w=10 l=10
X363 VGND blk05_0/n05_2 VGND VGND sky130_fd_pr__nfet_01v8 ad=0 pd=0 as=0 ps=0 w=10 l=10
X364 VGND blk05_0/n05_2 VGND VGND sky130_fd_pr__nfet_01v8 ad=0 pd=0 as=0 ps=0 w=10 l=10
X365 VGND blk05_0/n05_2 VGND VGND sky130_fd_pr__nfet_01v8 ad=0 pd=0 as=0 ps=0 w=10 l=10
X366 VGND blk05_0/n05_2 VGND VGND sky130_fd_pr__nfet_01v8 ad=0 pd=0 as=0 ps=0 w=10 l=10
X367 VGND blk05_0/n05_2 VGND VGND sky130_fd_pr__nfet_01v8 ad=0 pd=0 as=0 ps=0 w=10 l=10
X368 VGND blk05_0/n05_2 VGND VGND sky130_fd_pr__nfet_01v8 ad=0 pd=0 as=0 ps=0 w=10 l=10
X369 VGND blk05_0/n05_2 VGND VGND sky130_fd_pr__nfet_01v8 ad=0 pd=0 as=0 ps=0 w=10 l=10
X370 VGND blk05_0/n05_2 VGND VGND sky130_fd_pr__nfet_01v8 ad=0 pd=0 as=0 ps=0 w=10 l=10
X371 VGND blk05_0/n05_2 VGND VGND sky130_fd_pr__nfet_01v8 ad=0 pd=0 as=0 ps=0 w=10 l=10
X372 VGND blk05_0/n05_2 VGND VGND sky130_fd_pr__nfet_01v8 ad=0 pd=0 as=0 ps=0 w=10 l=10
X373 VGND blk05_0/n05_2 VGND VGND sky130_fd_pr__nfet_01v8 ad=0 pd=0 as=0 ps=0 w=10 l=10
X374 VGND blk05_0/n05_2 VGND VGND sky130_fd_pr__nfet_01v8 ad=0 pd=0 as=0 ps=0 w=10 l=10
X375 VGND blk05_0/n05_2 VGND VGND sky130_fd_pr__nfet_01v8 ad=0 pd=0 as=0 ps=0 w=10 l=10
X376 VGND blk05_0/n05_2 VGND VGND sky130_fd_pr__nfet_01v8 ad=0 pd=0 as=0 ps=0 w=10 l=10
X377 VGND blk05_0/n05_2 VGND VGND sky130_fd_pr__nfet_01v8 ad=0 pd=0 as=0 ps=0 w=10 l=10
X378 VGND blk05_0/n05_2 VGND VGND sky130_fd_pr__nfet_01v8 ad=0 pd=0 as=0 ps=0 w=10 l=10
X379 VGND blk05_0/n05_2 VGND VGND sky130_fd_pr__nfet_01v8 ad=0 pd=0 as=0 ps=0 w=10 l=10
X380 VGND blk05_0/n05_2 VGND VGND sky130_fd_pr__nfet_01v8 ad=0 pd=0 as=0 ps=0 w=10 l=10
X381 VGND blk05_0/n05_2 VGND VGND sky130_fd_pr__nfet_01v8 ad=0 pd=0 as=0 ps=0 w=10 l=10
X382 VGND blk05_0/n05_2 VGND VGND sky130_fd_pr__nfet_01v8 ad=0 pd=0 as=0 ps=0 w=10 l=10
X383 VGND blk05_0/n05_2 VGND VGND sky130_fd_pr__nfet_01v8 ad=0 pd=0 as=0 ps=0 w=10 l=10
X384 VGND blk05_0/n05_2 VGND VGND sky130_fd_pr__nfet_01v8 ad=0 pd=0 as=0 ps=0 w=10 l=10
X385 VGND blk05_0/n05_2 VGND VGND sky130_fd_pr__nfet_01v8 ad=0 pd=0 as=0 ps=0 w=10 l=10
X386 VGND blk05_0/n05_2 VGND VGND sky130_fd_pr__nfet_01v8 ad=0 pd=0 as=0 ps=0 w=10 l=10
X387 VGND blk05_0/n05_2 VGND VGND sky130_fd_pr__nfet_01v8 ad=0 pd=0 as=0 ps=0 w=10 l=10
X388 VGND blk05_0/n05_2 VGND VGND sky130_fd_pr__nfet_01v8 ad=0 pd=0 as=0 ps=0 w=10 l=10
X389 VGND blk05_0/n05_2 VGND VGND sky130_fd_pr__nfet_01v8 ad=0 pd=0 as=0 ps=0 w=10 l=10
X390 VGND blk05_0/n05_2 VGND VGND sky130_fd_pr__nfet_01v8 ad=1.45 pd=10.29 as=1.45 ps=10.29 w=10 l=10
X391 VGND blk05_0/n05_2 VGND VGND sky130_fd_pr__nfet_01v8 ad=1.45 pd=10.29 as=1.45 ps=10.29 w=10 l=10
X392 VGND blk05_0/n05_2 VGND VGND sky130_fd_pr__nfet_01v8 ad=1.45 pd=10.29 as=1.45 ps=10.29 w=10 l=10
X393 VGND blk05_0/n05_2 VGND VGND sky130_fd_pr__nfet_01v8 ad=1.45 pd=10.29 as=2.9 ps=20.58 w=10 l=10
X394 VGND blk05_0/n05_2 VGND VGND sky130_fd_pr__nfet_01v8 ad=2.9 pd=20.58 as=1.45 ps=10.29 w=10 l=10
X395 VGND blk05_0/n05_2 VGND VGND sky130_fd_pr__nfet_01v8 ad=1.45 pd=10.29 as=1.45 ps=10.29 w=10 l=10
X396 VGND blk05_0/n05_2 VGND VGND sky130_fd_pr__nfet_01v8 ad=1.45 pd=10.29 as=1.45 ps=10.29 w=10 l=10
X397 VGND blk05_0/n05_2 VGND VGND sky130_fd_pr__nfet_01v8 ad=1.45 pd=10.29 as=1.45 ps=10.29 w=10 l=10
X398 VGND blk05_0/n05_2 VGND VGND sky130_fd_pr__nfet_01v8 ad=1.45 pd=10.29 as=1.45 ps=10.29 w=10 l=10
X399 VGND blk05_0/n05_2 VGND VGND sky130_fd_pr__nfet_01v8 ad=1.45 pd=10.29 as=1.45 ps=10.29 w=10 l=10
X400 VGND blk05_0/n05_2 VGND VGND sky130_fd_pr__nfet_01v8 ad=1.45 pd=10.29 as=1.45 ps=10.29 w=10 l=10
X401 VGND blk05_0/n05_3 VGND VGND sky130_fd_pr__nfet_01v8 ad=0 pd=0 as=0 ps=0 w=10 l=10
X402 VGND blk05_0/n05_3 VGND VGND sky130_fd_pr__nfet_01v8 ad=0 pd=0 as=0 ps=0 w=10 l=10
X403 VGND blk05_0/n05_3 VGND VGND sky130_fd_pr__nfet_01v8 ad=0 pd=0 as=0 ps=0 w=10 l=10
X404 VGND blk05_0/n05_3 VGND VGND sky130_fd_pr__nfet_01v8 ad=0 pd=0 as=0 ps=0 w=10 l=10
X405 VGND blk05_0/n05_3 VGND VGND sky130_fd_pr__nfet_01v8 ad=0 pd=0 as=0 ps=0 w=10 l=10
X406 VGND blk05_0/n05_3 VGND VGND sky130_fd_pr__nfet_01v8 ad=0 pd=0 as=0 ps=0 w=10 l=10
X407 VGND blk05_0/n05_3 VGND VGND sky130_fd_pr__nfet_01v8 ad=0 pd=0 as=0 ps=0 w=10 l=10
X408 VGND blk05_0/n05_3 VGND VGND sky130_fd_pr__nfet_01v8 ad=0 pd=0 as=0 ps=0 w=10 l=10
X409 VGND blk05_0/n05_3 VGND VGND sky130_fd_pr__nfet_01v8 ad=0 pd=0 as=0 ps=0 w=10 l=10
X410 VGND blk05_0/n05_3 VGND VGND sky130_fd_pr__nfet_01v8 ad=0 pd=0 as=0 ps=0 w=10 l=10
X411 VGND blk05_0/n05_3 VGND VGND sky130_fd_pr__nfet_01v8 ad=0 pd=0 as=0 ps=0 w=10 l=10
X412 VGND blk05_0/n05_3 VGND VGND sky130_fd_pr__nfet_01v8 ad=0 pd=0 as=0 ps=0 w=10 l=10
X413 VGND blk05_0/n05_3 VGND VGND sky130_fd_pr__nfet_01v8 ad=0 pd=0 as=0 ps=0 w=10 l=10
X414 VGND blk05_0/n05_3 VGND VGND sky130_fd_pr__nfet_01v8 ad=0 pd=0 as=0 ps=0 w=10 l=10
X415 VGND blk05_0/n05_3 VGND VGND sky130_fd_pr__nfet_01v8 ad=0 pd=0 as=0 ps=0 w=10 l=10
X416 VGND blk05_0/n05_3 VGND VGND sky130_fd_pr__nfet_01v8 ad=0 pd=0 as=0 ps=0 w=10 l=10
X417 VGND blk05_0/n05_3 VGND VGND sky130_fd_pr__nfet_01v8 ad=0 pd=0 as=0 ps=0 w=10 l=10
X418 VGND blk05_0/n05_3 VGND VGND sky130_fd_pr__nfet_01v8 ad=0 pd=0 as=0 ps=0 w=10 l=10
X419 VGND blk05_0/n05_3 VGND VGND sky130_fd_pr__nfet_01v8 ad=0 pd=0 as=0 ps=0 w=10 l=10
X420 VGND blk05_0/n05_3 VGND VGND sky130_fd_pr__nfet_01v8 ad=0 pd=0 as=0 ps=0 w=10 l=10
X421 VGND blk05_0/n05_3 VGND VGND sky130_fd_pr__nfet_01v8 ad=0 pd=0 as=0 ps=0 w=10 l=10
X422 VGND blk05_0/n05_3 VGND VGND sky130_fd_pr__nfet_01v8 ad=0 pd=0 as=0 ps=0 w=10 l=10
X423 VGND blk05_0/n05_3 VGND VGND sky130_fd_pr__nfet_01v8 ad=0 pd=0 as=0 ps=0 w=10 l=10
X424 VGND blk05_0/n05_3 VGND VGND sky130_fd_pr__nfet_01v8 ad=0 pd=0 as=0 ps=0 w=10 l=10
X425 VGND blk05_0/n05_3 VGND VGND sky130_fd_pr__nfet_01v8 ad=0 pd=0 as=0 ps=0 w=10 l=10
X426 VGND blk05_0/n05_3 VGND VGND sky130_fd_pr__nfet_01v8 ad=0 pd=0 as=0 ps=0 w=10 l=10
X427 VGND blk05_0/n05_3 VGND VGND sky130_fd_pr__nfet_01v8 ad=0 pd=0 as=0 ps=0 w=10 l=10
X428 VGND blk05_0/n05_3 VGND VGND sky130_fd_pr__nfet_01v8 ad=0 pd=0 as=0 ps=0 w=10 l=10
X429 VGND blk05_0/n05_3 VGND VGND sky130_fd_pr__nfet_01v8 ad=0 pd=0 as=0 ps=0 w=10 l=10
X430 VGND blk05_0/n05_3 VGND VGND sky130_fd_pr__nfet_01v8 ad=0 pd=0 as=0 ps=0 w=10 l=10
X431 VGND blk05_0/n05_3 VGND VGND sky130_fd_pr__nfet_01v8 ad=0 pd=0 as=0 ps=0 w=10 l=10
X432 VGND blk05_0/n05_3 VGND VGND sky130_fd_pr__nfet_01v8 ad=0 pd=0 as=0 ps=0 w=10 l=10
X433 VGND blk05_0/n05_3 VGND VGND sky130_fd_pr__nfet_01v8 ad=0 pd=0 as=0 ps=0 w=10 l=10
X434 VGND blk05_0/n05_3 VGND VGND sky130_fd_pr__nfet_01v8 ad=0 pd=0 as=0 ps=0 w=10 l=10
X435 VGND blk05_0/n05_1 VGND VGND sky130_fd_pr__nfet_01v8 ad=0 pd=0 as=0 ps=0 w=10 l=10
X436 VGND blk05_0/n05_1 VGND VGND sky130_fd_pr__nfet_01v8 ad=0 pd=0 as=0 ps=0 w=10 l=10
X437 VGND blk05_0/n05_1 VGND VGND sky130_fd_pr__nfet_01v8 ad=0 pd=0 as=0 ps=0 w=10 l=10
X438 VGND blk05_0/n05_1 VGND VGND sky130_fd_pr__nfet_01v8 ad=0 pd=0 as=0 ps=0 w=10 l=10
X439 VGND blk05_0/n05_1 VGND VGND sky130_fd_pr__nfet_01v8 ad=0 pd=0 as=0 ps=0 w=10 l=10
X440 VGND blk05_0/n05_1 VGND VGND sky130_fd_pr__nfet_01v8 ad=0 pd=0 as=0 ps=0 w=10 l=10
X441 VGND blk05_0/n05_1 VGND VGND sky130_fd_pr__nfet_01v8 ad=0 pd=0 as=0 ps=0 w=10 l=10
X442 VGND blk05_0/n05_1 VGND VGND sky130_fd_pr__nfet_01v8 ad=0 pd=0 as=0 ps=0 w=10 l=10
X443 VGND blk05_0/n05_1 VGND VGND sky130_fd_pr__nfet_01v8 ad=0 pd=0 as=0 ps=0 w=10 l=10
X444 VGND blk05_0/n05_1 VGND VGND sky130_fd_pr__nfet_01v8 ad=0 pd=0 as=0 ps=0 w=10 l=10
X445 VGND blk05_0/n05_1 VGND VGND sky130_fd_pr__nfet_01v8 ad=0 pd=0 as=0 ps=0 w=10 l=10
X446 VGND blk05_0/n05_1 VGND VGND sky130_fd_pr__nfet_01v8 ad=0 pd=0 as=0 ps=0 w=10 l=10
X447 VGND blk05_0/n05_1 VGND VGND sky130_fd_pr__nfet_01v8 ad=0 pd=0 as=0 ps=0 w=10 l=10
X448 VGND blk05_0/n05_1 VGND VGND sky130_fd_pr__nfet_01v8 ad=0 pd=0 as=0 ps=0 w=10 l=10
X449 VGND blk05_0/n05_1 VGND VGND sky130_fd_pr__nfet_01v8 ad=0 pd=0 as=0 ps=0 w=10 l=10
X450 VGND blk05_0/n05_1 VGND VGND sky130_fd_pr__nfet_01v8 ad=0 pd=0 as=0 ps=0 w=10 l=10
X451 VGND blk05_0/n05_1 VGND VGND sky130_fd_pr__nfet_01v8 ad=0 pd=0 as=0 ps=0 w=10 l=10
X452 VGND blk05_0/n05_1 VGND VGND sky130_fd_pr__nfet_01v8 ad=0 pd=0 as=0 ps=0 w=10 l=10
X453 VGND blk05_0/n05_1 VGND VGND sky130_fd_pr__nfet_01v8 ad=0 pd=0 as=0 ps=0 w=10 l=10
X454 VGND blk05_0/n05_1 VGND VGND sky130_fd_pr__nfet_01v8 ad=0 pd=0 as=0 ps=0 w=10 l=10
X455 VGND blk05_0/n05_1 VGND VGND sky130_fd_pr__nfet_01v8 ad=0 pd=0 as=0 ps=0 w=10 l=10
X456 VGND blk05_0/n05_1 VGND VGND sky130_fd_pr__nfet_01v8 ad=0 pd=0 as=0 ps=0 w=10 l=10
X457 VGND blk05_0/n05_1 VGND VGND sky130_fd_pr__nfet_01v8 ad=0 pd=0 as=0 ps=0 w=10 l=10
X458 VGND blk05_0/n05_1 VGND VGND sky130_fd_pr__nfet_01v8 ad=0 pd=0 as=0 ps=0 w=10 l=10
X459 VGND blk05_0/n05_1 VGND VGND sky130_fd_pr__nfet_01v8 ad=0 pd=0 as=0 ps=0 w=10 l=10
X460 VGND blk05_0/n05_1 VGND VGND sky130_fd_pr__nfet_01v8 ad=0 pd=0 as=0 ps=0 w=10 l=10
X461 VGND blk05_0/n05_1 VGND VGND sky130_fd_pr__nfet_01v8 ad=0 pd=0 as=0 ps=0 w=10 l=10
X462 VGND blk05_0/n05_1 VGND VGND sky130_fd_pr__nfet_01v8 ad=0 pd=0 as=0 ps=0 w=10 l=10
X463 VGND blk05_0/n05_1 VGND VGND sky130_fd_pr__nfet_01v8 ad=0 pd=0 as=0 ps=0 w=10 l=10
X464 VGND blk05_0/n05_1 VGND VGND sky130_fd_pr__nfet_01v8 ad=0 pd=0 as=0 ps=0 w=10 l=10
X465 VGND blk05_0/n05_1 VGND VGND sky130_fd_pr__nfet_01v8 ad=0 pd=0 as=0 ps=0 w=10 l=10
X466 VGND blk05_0/n05_1 VGND VGND sky130_fd_pr__nfet_01v8 ad=0 pd=0 as=0 ps=0 w=10 l=10
X467 VGND blk05_0/n05_1 VGND VGND sky130_fd_pr__nfet_01v8 ad=0 pd=0 as=0 ps=0 w=10 l=10
X468 VGND blk05_0/n05_1 VGND VGND sky130_fd_pr__nfet_01v8 ad=0 pd=0 as=0 ps=0 w=10 l=10
X469 VGND blk05_0/n05_1 VGND VGND sky130_fd_pr__nfet_01v8 ad=0 pd=0 as=0 ps=0 w=10 l=10
X470 VGND blk05_0/n05_1 VGND VGND sky130_fd_pr__nfet_01v8 ad=0 pd=0 as=0 ps=0 w=10 l=10
X471 VGND blk05_0/n05_1 VGND VGND sky130_fd_pr__nfet_01v8 ad=0 pd=0 as=0 ps=0 w=10 l=10
X472 VGND blk05_0/n05_1 VGND VGND sky130_fd_pr__nfet_01v8 ad=0 pd=0 as=0 ps=0 w=10 l=10
X473 VGND blk05_0/n05_1 VGND VGND sky130_fd_pr__nfet_01v8 ad=0 pd=0 as=0 ps=0 w=10 l=10
X474 VGND blk05_0/n05_1 VGND VGND sky130_fd_pr__nfet_01v8 ad=0 pd=0 as=0 ps=0 w=10 l=10
X475 VGND blk05_0/n05_1 VGND VGND sky130_fd_pr__nfet_01v8 ad=0 pd=0 as=0 ps=0 w=10 l=10
X476 VGND blk05_0/n05_1 VGND VGND sky130_fd_pr__nfet_01v8 ad=0 pd=0 as=0 ps=0 w=10 l=10
X477 VGND blk05_0/n05_1 VGND VGND sky130_fd_pr__nfet_01v8 ad=0 pd=0 as=0 ps=0 w=10 l=10
X478 VGND blk05_0/n05_1 VGND VGND sky130_fd_pr__nfet_01v8 ad=0 pd=0 as=0 ps=0 w=10 l=10
X479 VGND blk05_0/n05_1 VGND VGND sky130_fd_pr__nfet_01v8 ad=0 pd=0 as=0 ps=0 w=10 l=10
X480 VGND blk05_0/n05_1 VGND VGND sky130_fd_pr__nfet_01v8 ad=0 pd=0 as=0 ps=0 w=10 l=10
X481 VGND blk05_0/n05_1 VGND VGND sky130_fd_pr__nfet_01v8 ad=0 pd=0 as=0 ps=0 w=10 l=10
X482 VGND blk05_0/n05_1 VGND VGND sky130_fd_pr__nfet_01v8 ad=0 pd=0 as=0 ps=0 w=10 l=10
X483 VGND blk05_0/n05_1 VGND VGND sky130_fd_pr__nfet_01v8 ad=0 pd=0 as=0 ps=0 w=10 l=10
X484 VGND blk05_0/n05_1 VGND VGND sky130_fd_pr__nfet_01v8 ad=0 pd=0 as=0 ps=0 w=10 l=10
X485 VGND blk05_0/n05_1 VGND VGND sky130_fd_pr__nfet_01v8 ad=0 pd=0 as=0 ps=0 w=10 l=10
X486 VGND blk05_0/n05_1 VGND VGND sky130_fd_pr__nfet_01v8 ad=0 pd=0 as=0 ps=0 w=10 l=10
X487 VGND blk05_0/n05_1 VGND VGND sky130_fd_pr__nfet_01v8 ad=0 pd=0 as=0 ps=0 w=10 l=10
X488 VGND blk05_0/n05_1 VGND VGND sky130_fd_pr__nfet_01v8 ad=0 pd=0 as=0 ps=0 w=10 l=10
X489 VGND blk05_0/n05_1 VGND VGND sky130_fd_pr__nfet_01v8 ad=0 pd=0 as=0 ps=0 w=10 l=10
X490 VGND blk05_0/n05_1 VGND VGND sky130_fd_pr__nfet_01v8 ad=0 pd=0 as=0 ps=0 w=10 l=10
X491 VGND blk05_0/n05_1 VGND VGND sky130_fd_pr__nfet_01v8 ad=0 pd=0 as=0 ps=0 w=10 l=10
X492 VGND blk05_0/n05_1 VGND VGND sky130_fd_pr__nfet_01v8 ad=0 pd=0 as=0 ps=0 w=10 l=10
X493 VGND blk05_0/n05_1 VGND VGND sky130_fd_pr__nfet_01v8 ad=0 pd=0 as=0 ps=0 w=10 l=10
X494 VGND blk05_0/n05_1 VGND VGND sky130_fd_pr__nfet_01v8 ad=0 pd=0 as=0 ps=0 w=10 l=10
X495 VGND blk05_0/n05_1 VGND VGND sky130_fd_pr__nfet_01v8 ad=0 pd=0 as=0 ps=0 w=10 l=10
X496 VGND blk05_0/n05_1 VGND VGND sky130_fd_pr__nfet_01v8 ad=0 pd=0 as=0 ps=0 w=10 l=10
X497 VGND blk05_0/n05_1 VGND VGND sky130_fd_pr__nfet_01v8 ad=0 pd=0 as=0 ps=0 w=10 l=10
X498 VGND blk05_0/n05_1 VGND VGND sky130_fd_pr__nfet_01v8 ad=0 pd=0 as=0 ps=0 w=10 l=10
X499 VGND blk05_0/n05_1 VGND VGND sky130_fd_pr__nfet_01v8 ad=0 pd=0 as=0 ps=0 w=10 l=10
X500 VGND blk05_0/n05_1 VGND VGND sky130_fd_pr__nfet_01v8 ad=0 pd=0 as=0 ps=0 w=10 l=10
X501 VGND blk05_0/n05_1 VGND VGND sky130_fd_pr__nfet_01v8 ad=0 pd=0 as=0 ps=0 w=10 l=10
X502 VGND blk05_0/n05_1 VGND VGND sky130_fd_pr__nfet_01v8 ad=0 pd=0 as=0 ps=0 w=10 l=10
X503 VGND blk05_0/n05_1 VGND VGND sky130_fd_pr__nfet_01v8 ad=0 pd=0 as=0 ps=0 w=10 l=10
X504 VGND blk05_0/n05_1 VGND VGND sky130_fd_pr__nfet_01v8 ad=0 pd=0 as=0 ps=0 w=10 l=10
X505 VGND blk05_0/n05_1 VGND VGND sky130_fd_pr__nfet_01v8 ad=0 pd=0 as=0 ps=0 w=10 l=10
X506 VGND blk05_0/n05_1 VGND VGND sky130_fd_pr__nfet_01v8 ad=0 pd=0 as=0 ps=0 w=10 l=10
X507 blk05_0/n05_1 VGND sky130_fd_pr__cap_mim_m3_1 l=23.25 w=29.96
X508 blk05_0/n05_1 VGND sky130_fd_pr__cap_mim_m3_1 l=23.25 w=29.96
X509 ua[1] swB4/S7 sky130_fd_pr__cap_mim_m3_1 l=19.86 w=29.8
X510 blk05_0/n05_2 VGND sky130_fd_pr__cap_mim_m3_1 l=28.57 w=29.96
X511 blk05_0/n05_1 VGND sky130_fd_pr__cap_mim_m3_1 l=23.25 w=29.96
X512 ua[1] swB4/S7 sky130_fd_pr__cap_mim_m3_1 l=19.86 w=29.8
X513 blk05_0/n05_2 VGND sky130_fd_pr__cap_mim_m3_1 l=28.57 w=29.96
X514 ua[1] swB3/S3 sky130_fd_pr__cap_mim_m3_1 l=19.86 w=29.8
X515 blk05_0/n05_3 VGND sky130_fd_pr__cap_mim_m3_1 l=25.16 w=29.96
X516 blk05_0/n05_2 VGND sky130_fd_pr__cap_mim_m3_1 l=28.57 w=29.96
X517 blk05_0/n05_1 VGND sky130_fd_pr__cap_mim_m3_1 l=23.25 w=29.96
X518 ua[1] swB4/S7 sky130_fd_pr__cap_mim_m3_1 l=19.86 w=29.8
X519 blk05_0/n05_2 VGND sky130_fd_pr__cap_mim_m3_1 l=28.57 w=29.96
X520 blk05_0/n05_1 VGND sky130_fd_pr__cap_mim_m3_1 l=23.25 w=29.96
X521 blk05_0/n05_3 VGND sky130_fd_pr__cap_mim_m3_1 l=25.16 w=29.96
X522 ua[1] swB4/S7 sky130_fd_pr__cap_mim_m3_1 l=19.86 w=29.8
X523 blk05_0/n05_1 VGND sky130_fd_pr__cap_mim_m3_1 l=23.25 w=29.96
X524 blk05_0/n05_1 VGND sky130_fd_pr__cap_mim_m3_1 l=23.25 w=29.96
X525 blk05_0/n05_2 VGND sky130_fd_pr__cap_mim_m3_1 l=28.57 w=29.96
X526 ua[1] swB3/S3 sky130_fd_pr__cap_mim_m3_1 l=19.86 w=29.8
X527 blk05_0/n05_3 VGND sky130_fd_pr__cap_mim_m3_1 l=25.16 w=29.96
X528 blk05_0/n05_2 VGND sky130_fd_pr__cap_mim_m3_1 l=28.57 w=29.96
X529 blk05_0/n05_1 VGND sky130_fd_pr__cap_mim_m3_1 l=23.25 w=29.96
X530 blk05_0/n05_3 VGND sky130_fd_pr__cap_mim_m3_1 l=25.16 w=29.96
X531 blk05_0/n05_1 VGND sky130_fd_pr__cap_mim_m3_1 l=23.25 w=29.96
X532 ua[1] swB2/S1 sky130_fd_pr__cap_mim_m3_1 l=19.86 w=29.8
X533 blk05_0/n05_2 VGND sky130_fd_pr__cap_mim_m3_1 l=28.57 w=29.96
X534 ua[1] swB0/S1 sky130_fd_pr__cap_mim_m3_1 l=19.86 w=7.33
X535 blk05_0/n05_1 VGND sky130_fd_pr__cap_mim_m3_1 l=23.25 w=29.96
X536 ua[1] swB1/S1 sky130_fd_pr__cap_mim_m3_1 l=19.86 w=14.82
X537 blk05_0/n05_2 VGND sky130_fd_pr__cap_mim_m3_1 l=28.57 w=29.96
X538 blk05_0/n05_1 VGND sky130_fd_pr__cap_mim_m3_1 l=23.25 w=29.96
X539 blk05_0/n05_1 VGND sky130_fd_pr__cap_mim_m3_1 l=23.25 w=29.96
X540 VDPWR sky130_fd_sc_hd__conb_1_10/HI sky130_fd_pr__res_generic_po w=0.48 l=0.5
X541 uio_out[5] VGND sky130_fd_pr__res_generic_po w=0.48 l=0.5
X542 VDPWR sky130_fd_sc_hd__conb_1_21/HI sky130_fd_pr__res_generic_po w=0.48 l=0.5
X543 uo_out[2] VGND sky130_fd_pr__res_generic_po w=0.48 l=0.5
X544 VGND uio_in[4] sky130_fd_pr__diode_pw2nd_05v5 perim=2.64e+06 area=4.347e+11
X545 VDPWR sky130_fd_sc_hd__buf_2_6/a_27_47# swA3/G VDPWR sky130_fd_pr__pfet_01v8_hvt ad=0 pd=0 as=0.27 ps=2.54 w=1 l=0.15
X546 swA3/G sky130_fd_sc_hd__buf_2_6/a_27_47# VDPWR VDPWR sky130_fd_pr__pfet_01v8_hvt ad=0 pd=0 as=0 ps=0 w=1 l=0.15
X547 VDPWR ui_in[3] sky130_fd_sc_hd__buf_2_6/a_27_47# VDPWR sky130_fd_pr__pfet_01v8_hvt ad=0 pd=0 as=0.1664 ps=1.8 w=0.64 l=0.15
X548 swA3/G sky130_fd_sc_hd__buf_2_6/a_27_47# VGND VGND sky130_fd_pr__nfet_01v8 ad=0.1755 pd=1.84 as=0 ps=0 w=0.65 l=0.15
X549 VGND sky130_fd_sc_hd__buf_2_6/a_27_47# swA3/G VGND sky130_fd_pr__nfet_01v8 ad=0 pd=0 as=0 ps=0 w=0.65 l=0.15
X550 VGND ui_in[3] sky130_fd_sc_hd__buf_2_6/a_27_47# VGND sky130_fd_pr__nfet_01v8 ad=0 pd=0 as=0.1092 ps=1.36 w=0.42 l=0.15
X551 VDPWR sky130_fd_sc_hd__conb_1_11/HI sky130_fd_pr__res_generic_po w=0.48 l=0.5
X552 uio_out[4] VGND sky130_fd_pr__res_generic_po w=0.48 l=0.5
X553 VDPWR sky130_fd_sc_hd__conb_1_22/HI sky130_fd_pr__res_generic_po w=0.48 l=0.5
X554 uo_out[1] VGND sky130_fd_pr__res_generic_po w=0.48 l=0.5
X555 VGND uio_in[3] sky130_fd_pr__diode_pw2nd_05v5 perim=2.64e+06 area=4.347e+11
X556 VDPWR sky130_fd_sc_hd__buf_2_7/a_27_47# swA2/G VDPWR sky130_fd_pr__pfet_01v8_hvt ad=0 pd=0 as=0.27 ps=2.54 w=1 l=0.15
X557 swA2/G sky130_fd_sc_hd__buf_2_7/a_27_47# VDPWR VDPWR sky130_fd_pr__pfet_01v8_hvt ad=0 pd=0 as=0 ps=0 w=1 l=0.15
X558 VDPWR ui_in[2] sky130_fd_sc_hd__buf_2_7/a_27_47# VDPWR sky130_fd_pr__pfet_01v8_hvt ad=0 pd=0 as=0.1664 ps=1.8 w=0.64 l=0.15
X559 swA2/G sky130_fd_sc_hd__buf_2_7/a_27_47# VGND VGND sky130_fd_pr__nfet_01v8 ad=0.1755 pd=1.84 as=0 ps=0 w=0.65 l=0.15
X560 VGND sky130_fd_sc_hd__buf_2_7/a_27_47# swA2/G VGND sky130_fd_pr__nfet_01v8 ad=0 pd=0 as=0 ps=0 w=0.65 l=0.15
X561 VGND ui_in[2] sky130_fd_sc_hd__buf_2_7/a_27_47# VGND sky130_fd_pr__nfet_01v8 ad=0 pd=0 as=0.1092 ps=1.36 w=0.42 l=0.15
X562 VDPWR sky130_fd_sc_hd__conb_1_23/HI sky130_fd_pr__res_generic_po w=0.48 l=0.5
X563 uo_out[0] VGND sky130_fd_pr__res_generic_po w=0.48 l=0.5
X564 VDPWR sky130_fd_sc_hd__conb_1_12/HI sky130_fd_pr__res_generic_po w=0.48 l=0.5
X565 uio_out[3] VGND sky130_fd_pr__res_generic_po w=0.48 l=0.5
X566 VDPWR sky130_fd_sc_hd__buf_2_8/a_27_47# swA1/G VDPWR sky130_fd_pr__pfet_01v8_hvt ad=0 pd=0 as=0.27 ps=2.54 w=1 l=0.15
X567 swA1/G sky130_fd_sc_hd__buf_2_8/a_27_47# VDPWR VDPWR sky130_fd_pr__pfet_01v8_hvt ad=0 pd=0 as=0 ps=0 w=1 l=0.15
X568 VDPWR ui_in[1] sky130_fd_sc_hd__buf_2_8/a_27_47# VDPWR sky130_fd_pr__pfet_01v8_hvt ad=0 pd=0 as=0.1664 ps=1.8 w=0.64 l=0.15
X569 swA1/G sky130_fd_sc_hd__buf_2_8/a_27_47# VGND VGND sky130_fd_pr__nfet_01v8 ad=0.1755 pd=1.84 as=0 ps=0 w=0.65 l=0.15
X570 VGND sky130_fd_sc_hd__buf_2_8/a_27_47# swA1/G VGND sky130_fd_pr__nfet_01v8 ad=0 pd=0 as=0 ps=0 w=0.65 l=0.15
X571 VGND ui_in[1] sky130_fd_sc_hd__buf_2_8/a_27_47# VGND sky130_fd_pr__nfet_01v8 ad=0 pd=0 as=0.1092 ps=1.36 w=0.42 l=0.15
X572 VGND uio_in[2] sky130_fd_pr__diode_pw2nd_05v5 perim=2.64e+06 area=4.347e+11
X573 VDPWR sky130_fd_sc_hd__conb_1_13/HI sky130_fd_pr__res_generic_po w=0.48 l=0.5
X574 uio_out[2] VGND sky130_fd_pr__res_generic_po w=0.48 l=0.5
X575 VGND uio_in[1] sky130_fd_pr__diode_pw2nd_05v5 perim=2.64e+06 area=4.347e+11
X576 VDPWR sky130_fd_sc_hd__buf_2_9/a_27_47# swA0/G VDPWR sky130_fd_pr__pfet_01v8_hvt ad=0 pd=0 as=0.27 ps=2.54 w=1 l=0.15
X577 swA0/G sky130_fd_sc_hd__buf_2_9/a_27_47# VDPWR VDPWR sky130_fd_pr__pfet_01v8_hvt ad=0 pd=0 as=0 ps=0 w=1 l=0.15
X578 VDPWR ui_in[0] sky130_fd_sc_hd__buf_2_9/a_27_47# VDPWR sky130_fd_pr__pfet_01v8_hvt ad=0 pd=0 as=0.1664 ps=1.8 w=0.64 l=0.15
X579 swA0/G sky130_fd_sc_hd__buf_2_9/a_27_47# VGND VGND sky130_fd_pr__nfet_01v8 ad=0.1755 pd=1.84 as=0 ps=0 w=0.65 l=0.15
X580 VGND sky130_fd_sc_hd__buf_2_9/a_27_47# swA0/G VGND sky130_fd_pr__nfet_01v8 ad=0 pd=0 as=0 ps=0 w=0.65 l=0.15
X581 VGND ui_in[0] sky130_fd_sc_hd__buf_2_9/a_27_47# VGND sky130_fd_pr__nfet_01v8 ad=0 pd=0 as=0.1092 ps=1.36 w=0.42 l=0.15
X582 VDPWR sky130_fd_sc_hd__conb_1_14/HI sky130_fd_pr__res_generic_po w=0.48 l=0.5
X583 uio_out[1] VGND sky130_fd_pr__res_generic_po w=0.48 l=0.5
X584 VGND uio_in[0] sky130_fd_pr__diode_pw2nd_05v5 perim=2.64e+06 area=4.347e+11
X585 VDPWR sky130_fd_sc_hd__conb_1_15/HI sky130_fd_pr__res_generic_po w=0.48 l=0.5
X586 uio_out[0] VGND sky130_fd_pr__res_generic_po w=0.48 l=0.5
X587 VGND ui_in[4] sky130_fd_pr__diode_pw2nd_05v5 perim=2.64e+06 area=4.347e+11
X588 VDPWR sky130_fd_sc_hd__conb_1_16/HI sky130_fd_pr__res_generic_po w=0.48 l=0.5
X589 uo_out[7] VGND sky130_fd_pr__res_generic_po w=0.48 l=0.5
X590 VGND ui_in[3] sky130_fd_pr__diode_pw2nd_05v5 perim=2.64e+06 area=4.347e+11
X591 VDPWR sky130_fd_sc_hd__conb_1_0/HI sky130_fd_pr__res_generic_po w=0.48 l=0.5
X592 uio_oe[7] VGND sky130_fd_pr__res_generic_po w=0.48 l=0.5
X593 VDPWR sky130_fd_sc_hd__conb_1_17/HI sky130_fd_pr__res_generic_po w=0.48 l=0.5
X594 uo_out[6] VGND sky130_fd_pr__res_generic_po w=0.48 l=0.5
X595 VGND ui_in[2] sky130_fd_pr__diode_pw2nd_05v5 perim=2.64e+06 area=4.347e+11
X596 VDPWR sky130_fd_sc_hd__conb_1_1/HI sky130_fd_pr__res_generic_po w=0.48 l=0.5
X597 uio_oe[6] VGND sky130_fd_pr__res_generic_po w=0.48 l=0.5
X598 VDPWR sky130_fd_sc_hd__conb_1_18/HI sky130_fd_pr__res_generic_po w=0.48 l=0.5
X599 uo_out[5] VGND sky130_fd_pr__res_generic_po w=0.48 l=0.5
X600 VGND ui_in[1] sky130_fd_pr__diode_pw2nd_05v5 perim=2.64e+06 area=4.347e+11
X601 VDPWR sky130_fd_sc_hd__conb_1_2/HI sky130_fd_pr__res_generic_po w=0.48 l=0.5
X602 uio_oe[5] VGND sky130_fd_pr__res_generic_po w=0.48 l=0.5
X603 VDPWR sky130_fd_sc_hd__conb_1_19/HI sky130_fd_pr__res_generic_po w=0.48 l=0.5
X604 uo_out[4] VGND sky130_fd_pr__res_generic_po w=0.48 l=0.5
X605 VGND ui_in[0] sky130_fd_pr__diode_pw2nd_05v5 perim=2.64e+06 area=4.347e+11
X606 VDPWR sky130_fd_sc_hd__conb_1_3/HI sky130_fd_pr__res_generic_po w=0.48 l=0.5
X607 uio_oe[4] VGND sky130_fd_pr__res_generic_po w=0.48 l=0.5
X608 swB0/S1 swB0/G VGND VGND sky130_fd_pr__nfet_01v8 ad=0.2475 pd=1.83 as=0.465 ps=3.62 w=1.5 l=0.15
X609 VGND swB0/G swB0/S1 VGND sky130_fd_pr__nfet_01v8 ad=0.465 pd=3.62 as=0.2475 ps=1.83 w=1.5 l=0.15
X610 swB1/S1 swB1/G VGND VGND sky130_fd_pr__nfet_01v8 ad=0.495 pd=3.33 as=0.93 ps=6.62 w=3 l=0.15
X611 VGND swB1/G swB1/S1 VGND sky130_fd_pr__nfet_01v8 ad=0.93 pd=6.62 as=0.495 ps=3.33 w=3 l=0.15
X612 swA0/S1 swA0/G VGND VGND sky130_fd_pr__nfet_01v8 ad=0.495 pd=3.66 as=0 ps=0 w=1.5 l=0.15
X613 VGND swA0/G swA0/S1 VGND sky130_fd_pr__nfet_01v8 ad=0 pd=0 as=0 ps=0 w=1.5 l=0.15
X614 VDPWR sky130_fd_sc_hd__conb_1_4/HI sky130_fd_pr__res_generic_po w=0.48 l=0.5
X615 uio_oe[3] VGND sky130_fd_pr__res_generic_po w=0.48 l=0.5
X616 VDPWR sky130_fd_sc_hd__conb_1_5/HI sky130_fd_pr__res_generic_po w=0.48 l=0.5
X617 uio_oe[2] VGND sky130_fd_pr__res_generic_po w=0.48 l=0.5
X618 swA1/S1 swA1/G VGND VGND sky130_fd_pr__nfet_01v8 ad=0.99 pd=6.66 as=0 ps=0 w=3 l=0.15
X619 VGND swA1/G swA1/S1 VGND sky130_fd_pr__nfet_01v8 ad=0 pd=0 as=0 ps=0 w=3 l=0.15
X620 swB2/S1 swB2/G VGND VGND sky130_fd_pr__nfet_01v8 ad=0.99 pd=6.33 as=1.86 ps=12.62 w=6 l=0.15
X621 VGND swB2/G swB2/S1 VGND sky130_fd_pr__nfet_01v8 ad=1.86 pd=12.62 as=0.99 ps=6.33 w=6 l=0.15
X622 resarr_0/r_07R1/R1_3 resarr_0/r_07R1/R2_4 VGND sky130_fd_pr__res_xhigh_po_0p35 l=98.45
X623 resarr_0/r_07R1/R1_1 resarr_0/r_07R1/R2_2 VGND sky130_fd_pr__res_xhigh_po_0p35 l=98.45
X624 resarr_0/r_07R1/R1_5 resarr_0/r_07R1/R2_6 VGND sky130_fd_pr__res_xhigh_po_0p35 l=98.45
X625 resarr_0/r_07R1/R1_3 resarr_0/r_07R1/R2_2 VGND sky130_fd_pr__res_xhigh_po_0p35 l=98.45
X626 resarr_0/r_07R1/R1_5 resarr_0/r_07R1/R2_4 VGND sky130_fd_pr__res_xhigh_po_0p35 l=98.45
X627 resarr_0/r_07R1/R1_1 ua[0] VGND sky130_fd_pr__res_xhigh_po_0p35 l=98.45
X628 blk07_0/n07_1 resarr_0/r_07R1/R2_6 VGND sky130_fd_pr__res_xhigh_po_0p35 l=98.45
X629 resarr_0/r_07R2/R1_1 resarr_0/r_07R2/R2_2 VGND sky130_fd_pr__res_xhigh_po_0p35 l=73.02
X630 resarr_0/r_07R2/R1_1 ua[0] VGND sky130_fd_pr__res_xhigh_po_0p35 l=73.02
X631 blk07_0/n07_2 resarr_0/r_07R2/R2_2 VGND sky130_fd_pr__res_xhigh_po_0p35 l=73.02
X632 blk07_0/n07_3 ua[0] VGND sky130_fd_pr__res_xhigh_po_0p35 l=57.8
X633 resarr_0/r_05R1/R1_1 resarr_0/r_05R1/R2_2 VGND sky130_fd_pr__res_xhigh_po_0p35 l=34.41
X634 resarr_0/r_05R1/R1_1 ua[1] VGND sky130_fd_pr__res_xhigh_po_0p35 l=34.41
X635 blk05_0/n05_1 resarr_0/r_05R1/R2_2 VGND sky130_fd_pr__res_xhigh_po_0p35 l=34.41
X636 VGND VGND VGND sky130_fd_pr__res_xhigh_po_0p35 l=2.6
X637 blk07_0/n07_4 ua[0] VGND sky130_fd_pr__res_xhigh_po_0p35 l=14.92
X638 blk07_0/n07_5 ua[0] VGND sky130_fd_pr__res_xhigh_po_0p35 l=2.6
X639 blk05_0/n05_2 ua[1] VGND sky130_fd_pr__res_xhigh_po_0p35 l=38.77
X640 blk05_0/n05_3 ua[1] VGND sky130_fd_pr__res_xhigh_po_0p35 l=8.82
X641 resarr_0/r_07Rp/R1_17 resarr_0/r_07Rp/R2_16 VGND sky130_fd_pr__res_xhigh_po_0p35 l=98.43
X642 resarr_0/r_07Rp/R1_11 resarr_0/r_07Rp/R2_9 VGND sky130_fd_pr__res_xhigh_po_0p35 l=98.43
X643 resarr_0/r_07Rp/R1_11 resarr_0/r_07Rp/R2_12 VGND sky130_fd_pr__res_xhigh_po_0p35 l=98.43
X644 resarr_0/r_07Rp/R1_25 resarr_0/r_07Rp/R2_24 VGND sky130_fd_pr__res_xhigh_po_0p35 l=98.43
X645 resarr_0/r_07Rp/R1_21 resarr_0/r_07Rp/R2_22 VGND sky130_fd_pr__res_xhigh_po_0p35 l=98.43
X646 resarr_0/r_07Rp/R1_7 resarr_0/r_07Rp/R2_8 VGND sky130_fd_pr__res_xhigh_po_0p35 l=98.43
X647 resarr_0/r_07Rp/R1_3 resarr_0/r_07Rp/R2_4 VGND sky130_fd_pr__res_xhigh_po_0p35 l=98.43
X648 resarr_0/r_07Rp/R1_27 resarr_0/r_07Rp/R2_28 VGND sky130_fd_pr__res_xhigh_po_0p35 l=98.43
X649 resarr_0/r_07Rp/R1_31 VGND VGND sky130_fd_pr__res_xhigh_po_0p35 l=98.43
X650 resarr_0/r_07Rp/R1_31 resarr_0/r_07Rp/R2_30 VGND sky130_fd_pr__res_xhigh_po_0p35 l=98.43
X651 resarr_0/r_07Rp/R1_1 ua[0] VGND sky130_fd_pr__res_xhigh_po_0p35 l=98.43
X652 resarr_0/r_07Rp/R1_5 resarr_0/r_07Rp/R2_4 VGND sky130_fd_pr__res_xhigh_po_0p35 l=98.43
X653 resarr_0/r_07Rp/R1_17 resarr_0/r_07Rp/R2_18 VGND sky130_fd_pr__res_xhigh_po_0p35 l=98.43
X654 resarr_0/r_07Rp/R1_1 resarr_0/r_07Rp/R2_2 VGND sky130_fd_pr__res_xhigh_po_0p35 l=98.43
X655 resarr_0/r_07Rp/R1_9 resarr_0/r_07Rp/R2_8 VGND sky130_fd_pr__res_xhigh_po_0p35 l=98.43
X656 resarr_0/r_07Rp/R1_23 resarr_0/r_07Rp/R2_24 VGND sky130_fd_pr__res_xhigh_po_0p35 l=98.43
X657 resarr_0/r_07Rp/R1_21 resarr_0/r_07Rp/R2_20 VGND sky130_fd_pr__res_xhigh_po_0p35 l=98.43
X658 resarr_0/r_07Rp/R1_15 resarr_0/r_07Rp/R2_16 VGND sky130_fd_pr__res_xhigh_po_0p35 l=98.43
X659 resarr_0/r_07Rp/R1_5 resarr_0/r_07Rp/R2_6 VGND sky130_fd_pr__res_xhigh_po_0p35 l=98.43
X660 resarr_0/r_07Rp/R1_3 resarr_0/r_07Rp/R2_2 VGND sky130_fd_pr__res_xhigh_po_0p35 l=98.43
X661 resarr_0/r_07Rp/R1_13 resarr_0/r_07Rp/R2_12 VGND sky130_fd_pr__res_xhigh_po_0p35 l=98.43
X662 resarr_0/r_07Rp/R1_23 resarr_0/r_07Rp/R2_22 VGND sky130_fd_pr__res_xhigh_po_0p35 l=98.43
X663 resarr_0/r_07Rp/R1_19 resarr_0/r_07Rp/R2_18 VGND sky130_fd_pr__res_xhigh_po_0p35 l=98.43
X664 resarr_0/r_07Rp/R1_19 resarr_0/r_07Rp/R2_20 VGND sky130_fd_pr__res_xhigh_po_0p35 l=98.43
X665 resarr_0/r_07Rp/R1_9 resarr_0/r_07Rp/R2_9 VGND sky130_fd_pr__res_xhigh_po_0p35 l=98.43
X666 resarr_0/r_07Rp/R1_25 resarr_0/r_07Rp/R2_26 VGND sky130_fd_pr__res_xhigh_po_0p35 l=98.43
X667 resarr_0/r_07Rp/R1_27 resarr_0/r_07Rp/R2_26 VGND sky130_fd_pr__res_xhigh_po_0p35 l=98.43
X668 resarr_0/r_07Rp/R1_29 resarr_0/r_07Rp/R2_28 VGND sky130_fd_pr__res_xhigh_po_0p35 l=98.43
X669 resarr_0/r_07Rp/R1_29 resarr_0/r_07Rp/R2_30 VGND sky130_fd_pr__res_xhigh_po_0p35 l=98.43
X670 resarr_0/r_07Rp/R1_7 resarr_0/r_07Rp/R2_6 VGND sky130_fd_pr__res_xhigh_po_0p35 l=98.43
X671 resarr_0/r_07Rp/R1_13 resarr_0/r_07Rp/R2_14 VGND sky130_fd_pr__res_xhigh_po_0p35 l=98.43
X672 resarr_0/r_07Rp/R1_15 resarr_0/r_07Rp/R2_14 VGND sky130_fd_pr__res_xhigh_po_0p35 l=98.43
X673 resarr_0/r_05Rp/R1_1 ua[1] VGND sky130_fd_pr__res_xhigh_po_0p35 l=59.65
X674 resarr_0/r_05Rp/R1_1 VGND VGND sky130_fd_pr__res_xhigh_po_0p35 l=59.65
X675 swA2/S1 swA2/G VGND VGND sky130_fd_pr__nfet_01v8 ad=1.98 pd=12.66 as=0 ps=0 w=6 l=0.15
X676 VGND swA2/G swA2/S1 VGND sky130_fd_pr__nfet_01v8 ad=0 pd=0 as=0 ps=0 w=6 l=0.15
X677 swB3/S3 swB3/G VGND VGND sky130_fd_pr__nfet_01v8 ad=0.99 pd=6.33 as=1.86 ps=12.62 w=6 l=0.15
X678 VGND swB3/G swB3/S3 VGND sky130_fd_pr__nfet_01v8 ad=0.99 pd=6.33 as=0.99 ps=6.33 w=6 l=0.15
X679 VGND swB3/G swB3/S3 VGND sky130_fd_pr__nfet_01v8 ad=1.86 pd=12.62 as=0.99 ps=6.33 w=6 l=0.15
X680 swB3/S3 swB3/G VGND VGND sky130_fd_pr__nfet_01v8 ad=0.99 pd=6.33 as=0.99 ps=6.33 w=6 l=0.15
X681 VDPWR sky130_fd_sc_hd__conb_1_6/HI sky130_fd_pr__res_generic_po w=0.48 l=0.5
X682 uio_oe[1] VGND sky130_fd_pr__res_generic_po w=0.48 l=0.5
X683 VDPWR sky130_fd_sc_hd__conb_1_7/HI sky130_fd_pr__res_generic_po w=0.48 l=0.5
X684 uio_oe[0] VGND sky130_fd_pr__res_generic_po w=0.48 l=0.5
X685 swA3/S3 swA3/G VGND VGND sky130_fd_pr__nfet_01v8 ad=3.96 pd=25.32 as=0 ps=0 w=6 l=0.15
X686 VGND swA3/G swA3/S3 VGND sky130_fd_pr__nfet_01v8 ad=0 pd=0 as=0 ps=0 w=6 l=0.15
X687 VGND swA3/G swA3/S3 VGND sky130_fd_pr__nfet_01v8 ad=0 pd=0 as=0 ps=0 w=6 l=0.15
X688 swA3/S3 swA3/G VGND VGND sky130_fd_pr__nfet_01v8 ad=0 pd=0 as=0 ps=0 w=6 l=0.15
X689 swB4/S7 swB4/G VGND VGND sky130_fd_pr__nfet_01v8 ad=0.99 pd=6.33 as=0.99 ps=6.33 w=6 l=0.15
X690 VGND swB4/G swB4/S7 VGND sky130_fd_pr__nfet_01v8 ad=1.86 pd=12.62 as=0.99 ps=6.33 w=6 l=0.15
X691 VGND swB4/G swB4/S7 VGND sky130_fd_pr__nfet_01v8 ad=0.99 pd=6.33 as=0.99 ps=6.33 w=6 l=0.15
X692 swB4/S7 swB4/G VGND VGND sky130_fd_pr__nfet_01v8 ad=0.99 pd=6.33 as=0.99 ps=6.33 w=6 l=0.15
X693 swB4/S7 swB4/G VGND VGND sky130_fd_pr__nfet_01v8 ad=0.99 pd=6.33 as=1.86 ps=12.62 w=6 l=0.15
X694 VGND swB4/G swB4/S7 VGND sky130_fd_pr__nfet_01v8 ad=0.99 pd=6.33 as=0.99 ps=6.33 w=6 l=0.15
X695 VGND swB4/G swB4/S7 VGND sky130_fd_pr__nfet_01v8 ad=0.99 pd=6.33 as=0.99 ps=6.33 w=6 l=0.15
X696 swB4/S7 swB4/G VGND VGND sky130_fd_pr__nfet_01v8 ad=0.99 pd=6.33 as=0.99 ps=6.33 w=6 l=0.15
X697 VDPWR sky130_fd_sc_hd__conb_1_8/HI sky130_fd_pr__res_generic_po w=0.48 l=0.5
X698 uio_out[7] VGND sky130_fd_pr__res_generic_po w=0.48 l=0.5
X699 swA4/S7 swA4/G VGND VGND sky130_fd_pr__nfet_01v8 ad=7.92 pd=50.64 as=0 ps=0 w=6 l=0.15
X700 VGND swA4/G swA4/S7 VGND sky130_fd_pr__nfet_01v8 ad=0 pd=0 as=0 ps=0 w=6 l=0.15
X701 VGND swA4/G swA4/S7 VGND sky130_fd_pr__nfet_01v8 ad=0 pd=0 as=0 ps=0 w=6 l=0.15
X702 swA4/S7 swA4/G VGND VGND sky130_fd_pr__nfet_01v8 ad=0 pd=0 as=0 ps=0 w=6 l=0.15
X703 swA4/S7 swA4/G VGND VGND sky130_fd_pr__nfet_01v8 ad=0 pd=0 as=0 ps=0 w=6 l=0.15
X704 VGND swA4/G swA4/S7 VGND sky130_fd_pr__nfet_01v8 ad=0 pd=0 as=0 ps=0 w=6 l=0.15
X705 VGND swA4/G swA4/S7 VGND sky130_fd_pr__nfet_01v8 ad=0 pd=0 as=0 ps=0 w=6 l=0.15
X706 swA4/S7 swA4/G VGND VGND sky130_fd_pr__nfet_01v8 ad=0 pd=0 as=0 ps=0 w=6 l=0.15
X707 VDPWR sky130_fd_sc_hd__conb_1_9/HI sky130_fd_pr__res_generic_po w=0.48 l=0.5
X708 uio_out[6] VGND sky130_fd_pr__res_generic_po w=0.48 l=0.5
C0 sky130_fd_sc_hd__buf_2_0/a_27_47# VDPWR 0.22456f
C1 sky130_fd_sc_hd__buf_2_0/a_27_47# swB4/G 0.17317f
C2 sky130_fd_sc_hd__buf_2_0/a_27_47# uio_in[4] 0.26287f
C3 sky130_fd_sc_hd__buf_2_0/a_27_47# uio_in[3] 0.01798f
C4 sky130_fd_sc_hd__buf_2_1/a_27_47# uio_in[2] 0.01798f
C5 sky130_fd_sc_hd__buf_2_1/a_27_47# VDPWR 0.22424f
C6 sky130_fd_sc_hd__buf_2_1/a_27_47# swB3/G 0.17337f
C7 sky130_fd_sc_hd__buf_2_1/a_27_47# uio_in[3] 0.26287f
C8 sky130_fd_sc_hd__buf_2_2/a_27_47# uio_in[2] 0.26287f
C9 sky130_fd_sc_hd__buf_2_2/a_27_47# VDPWR 0.22424f
C10 sky130_fd_sc_hd__buf_2_2/a_27_47# swB2/G 0.17363f
C11 sky130_fd_sc_hd__buf_2_2/a_27_47# uio_in[1] 0.01798f
C12 uio_in[2] VDPWR 0.47945f
C13 uio_in[2] swB2/G 0.05431f
C14 uio_in[2] swB3/G 0.09965f
C15 uio_in[2] uio_in[3] 0.17888f
C16 uio_in[2] uio_in[1] 0.17888f
C17 blk07_0/n07_4 blk07_0/n07_5 20.81814f
C18 blk07_0/n07_4 blk07_0/n07_1 0.09288f
C19 blk07_0/n07_4 blk07_0/n07_2 0.19121f
C20 blk07_0/n07_4 blk07_0/n07_3 19.2427f
C21 blk07_0/n07_4 blk05_0/n05_3 5.51165f
C22 blk07_0/n07_4 blk05_0/n05_1 4.27093f
C23 blk07_0/n07_4 swA0/G 0.04397f
C24 blk07_0/n07_4 swA1/G 0.03218f
C25 blk07_0/n07_4 swA2/G 0.0322f
C26 blk07_0/n07_4 swA3/G 0.03221f
C27 blk07_0/n07_4 swA4/G 0.04314f
C28 blk07_0/n07_5 blk07_0/n07_1 0.08398f
C29 blk07_0/n07_5 blk07_0/n07_2 0.14537f
C30 blk07_0/n07_5 blk07_0/n07_3 0.15618f
C31 blk07_0/n07_5 blk05_0/n05_3 5.8465f
C32 blk07_0/n07_5 swA0/G 0.05452f
C33 blk07_0/n07_5 swA1/G 0.04273f
C34 blk07_0/n07_5 ua[0] 0.01208f
C35 blk07_0/n07_5 swA2/G 0.04275f
C36 blk07_0/n07_5 swA3/G 0.04279f
C37 blk07_0/n07_5 swA4/G 1.03271f
C38 blk07_0/n07_1 blk07_0/n07_2 36.80478f
C39 blk07_0/n07_1 blk07_0/n07_3 0.12533f
C40 blk07_0/n07_1 swA4/S7 50.51804f
C41 blk07_0/n07_1 swA0/S1 7.10813f
C42 blk07_0/n07_1 swA1/S1 8.67605f
C43 blk07_0/n07_1 swA2/S1 13.44094f
C44 blk07_0/n07_1 swA3/S3 24.99602f
C45 blk07_0/n07_1 blk05_0/n05_2 0.05735f
C46 blk07_0/n07_1 blk05_0/n05_3 0.05106f
C47 blk07_0/n07_1 blk05_0/n05_1 0.10809f
C48 blk07_0/n07_1 swA0/G 0.05436f
C49 blk07_0/n07_1 swA1/G 0.04256f
C50 blk07_0/n07_1 resarr_0/r_07R1/R1_5 0.28858f
C51 blk07_0/n07_1 ua[0] 15.42163f
C52 blk07_0/n07_1 swA2/G 0.04256f
C53 blk07_0/n07_1 swA3/G 0.04256f
C54 blk07_0/n07_1 swA4/G 0.055f
C55 blk07_0/n07_2 blk07_0/n07_3 34.74101f
C56 blk07_0/n07_2 blk05_0/n05_2 0.04799f
C57 blk07_0/n07_2 blk05_0/n05_3 0.04096f
C58 blk07_0/n07_2 blk05_0/n05_1 0.1107f
C59 blk07_0/n07_2 swA0/G 0.04391f
C60 blk07_0/n07_2 swA1/G 0.03211f
C61 blk07_0/n07_2 resarr_0/r_07R2/R1_1 0.28856f
C62 blk07_0/n07_2 swA2/G 0.03211f
C63 blk07_0/n07_2 swA3/G 0.03211f
C64 blk07_0/n07_2 swA4/G 0.04303f
C65 blk07_0/n07_3 blk05_0/n05_2 2.87652f
C66 blk07_0/n07_3 blk05_0/n05_3 0.05024f
C67 blk07_0/n07_3 blk05_0/n05_1 0.18198f
C68 blk07_0/n07_3 swA0/G 0.04391f
C69 blk07_0/n07_3 swA1/G 0.03211f
C70 blk07_0/n07_3 resarr_0/r_05Rp/R1_1 0.07275f
C71 blk07_0/n07_3 swA2/G 0.03211f
C72 blk07_0/n07_3 swA3/G 0.03211f
C73 blk07_0/n07_3 swA4/G 0.04303f
C74 swA4/S7 swA0/S1 11.22047f
C75 swA4/S7 swA1/S1 0.1263f
C76 swA4/S7 swA2/S1 0.12701f
C77 swA4/S7 swA3/S3 0.85004f
C78 swA4/S7 ua[0] 0.25596p
C79 swA4/S7 swA4/G 0.84899f
C80 swA0/S1 swA1/S1 15.64414f
C81 swA0/S1 swA0/G 0.10597f
C82 swA0/S1 swA1/G 0.02428f
C83 swA0/S1 ua[0] 32.63271f
C84 swA0/S1 swA4/G 0.01089f
C85 swA1/S1 swA2/S1 13.11909f
C86 swA1/S1 swA1/G 0.13819f
C87 swA1/S1 ua[0] 44.37581f
C88 swA1/S1 swA2/G 0.02744f
C89 swA1/S1 swA4/G 0.03637f
C90 swA2/S1 swA3/S3 9.84435f
C91 swA2/S1 ua[0] 72.20336f
C92 swA2/S1 swA2/G 0.20769f
C93 swA2/S1 swA3/G 0.04032f
C94 swA2/S1 swA4/G 0.02868f
C95 swA3/S3 ua[0] 0.13068p
C96 swA3/S3 swA3/G 0.43298f
C97 swA3/S3 swA4/G 0.06184f
C98 sky130_fd_sc_hd__buf_2_3/a_27_47# VDPWR 0.22424f
C99 sky130_fd_sc_hd__buf_2_3/a_27_47# swB1/G 0.17397f
C100 sky130_fd_sc_hd__buf_2_3/a_27_47# uio_in[1] 0.26287f
C101 sky130_fd_sc_hd__buf_2_3/a_27_47# uio_in[0] 0.01798f
C102 sky130_fd_sc_hd__buf_2_4/a_27_47# VDPWR 0.22699f
C103 sky130_fd_sc_hd__buf_2_4/a_27_47# swB0/G 0.17439f
C104 sky130_fd_sc_hd__buf_2_4/a_27_47# uio_in[0] 0.26287f
C105 sky130_fd_sc_hd__conb_1_20/HI uo_out[3] 0.08925f
C106 sky130_fd_sc_hd__conb_1_20/HI VDPWR 0.06414f
C107 sky130_fd_sc_hd__conb_1_20/HI uo_out[4] 0.01019f
C108 uo_out[3] sky130_fd_sc_hd__conb_1_21/HI 0.01019f
C109 uo_out[3] uo_out[2] 0.19403f
C110 uo_out[3] VDPWR 0.60019f
C111 uo_out[3] uo_out[4] 0.19403f
C112 sky130_fd_sc_hd__buf_2_5/a_27_47# ui_in[3] 0.01798f
C113 sky130_fd_sc_hd__buf_2_5/a_27_47# VDPWR 0.22455f
C114 sky130_fd_sc_hd__buf_2_5/a_27_47# swA4/G 0.17652f
C115 sky130_fd_sc_hd__buf_2_5/a_27_47# ui_in[4] 0.26287f
C116 blk05_0/n05_2 blk05_0/n05_3 23.29981f
C117 blk05_0/n05_2 blk05_0/n05_1 23.07855f
C118 blk05_0/n05_2 swB0/G 0.04391f
C119 blk05_0/n05_2 swB1/G 0.03211f
C120 blk05_0/n05_2 swB2/G 0.03211f
C121 blk05_0/n05_2 swB3/G 0.03211f
C122 blk05_0/n05_2 swB4/G 0.04391f
C123 blk05_0/n05_3 blk05_0/n05_1 0.20756f
C124 blk05_0/n05_3 VDPWR 0.14218f
C125 blk05_0/n05_3 swB0/G 0.64253f
C126 blk05_0/n05_3 swB1/G 0.07353f
C127 blk05_0/n05_3 swA0/G 0.01374f
C128 blk05_0/n05_3 swA1/G 0.1908f
C129 blk05_0/n05_3 swB2/G 0.08217f
C130 blk05_0/n05_3 swA2/G 0.02161f
C131 blk05_0/n05_3 swB3/G 0.11699f
C132 blk05_0/n05_3 swA3/G 0.01487f
C133 blk05_0/n05_3 swB4/G 0.30955f
C134 blk05_0/n05_3 swA4/G 0.0373f
C135 blk05_0/n05_1 swB4/S7 50.52635f
C136 blk05_0/n05_1 swB0/S1 6.93288f
C137 blk05_0/n05_1 swB1/S1 8.76536f
C138 blk05_0/n05_1 swB2/S1 13.51998f
C139 blk05_0/n05_1 swB3/S3 25.00993f
C140 blk05_0/n05_1 ua[1] 15.35859f
C141 blk05_0/n05_1 swB0/G 0.05905f
C142 blk05_0/n05_1 swB1/G 0.04737f
C143 blk05_0/n05_1 swB2/G 0.04715f
C144 blk05_0/n05_1 resarr_0/r_05R1/R1_1 0.28856f
C145 blk05_0/n05_1 swB3/G 0.04867f
C146 blk05_0/n05_1 swB4/G 0.06598f
C147 swB4/S7 swB0/S1 11.10294f
C148 swB4/S7 swB1/S1 0.04389f
C149 swB4/S7 swB2/S1 0.04795f
C150 swB4/S7 swB3/S3 0.80044f
C151 swB4/S7 ua[1] 0.25634p
C152 swB4/S7 swB4/G 0.8503f
C153 swB0/S1 swB1/S1 15.71111f
C154 swB0/S1 swB2/S1 0.07462f
C155 swB0/S1 swB3/S3 0.07968f
C156 swB0/S1 ua[1] 30.72945f
C157 swB0/S1 swB0/G 0.1685f
C158 swB0/S1 swB1/G 0.14118f
C159 swB0/S1 swB2/G 0.1119f
C160 swB0/S1 swB3/G 0.12438f
C161 swB0/S1 swB4/G 0.13075f
C162 swB1/S1 swB2/S1 13.06974f
C163 swB1/S1 swB3/S3 0.09852f
C164 swB1/S1 ua[1] 44.19418f
C165 swB1/S1 swB1/G 0.1506f
C166 swB1/S1 swB2/G 0.05696f
C167 swB1/S1 swB3/G 0.04407f
C168 swB1/S1 swB4/G 0.04357f
C169 swB2/S1 swB3/S3 9.93554f
C170 swB2/S1 ua[1] 72.08154f
C171 swB2/S1 swB2/G 0.20411f
C172 swB2/S1 swB3/G 0.045f
C173 swB2/S1 swB4/G 0.031f
C174 swB3/S3 ua[1] 0.13153p
C175 swB3/S3 swB3/G 0.40957f
C176 swB3/S3 swB4/G 0.0445f
C177 ua[1] resarr_0/r_07R1/R2_2 0.01064f
C178 ua[1] resarr_0/r_07R1/R2_4 0.01135f
C179 ua[1] resarr_0/r_07R1/R2_6 0.01306f
C180 ua[1] resarr_0/r_07R2/R2_2 0.30396f
C181 ua[1] resarr_0/r_05R1/R2_2 0.31273f
C182 ua[1] ua[0] 2.68733f
C183 ua[1] swB4/G 0.02064f
C184 ua[1] ua[7] 0.05551f
C185 ua[1] ua[6] 0.05551f
C186 ua[1] ua[5] 0.05551f
C187 ua[1] ua[4] 0.05551f
C188 ua[1] ua[3] 0.05551f
C189 ua[1] ua[2] 0.05551f
C190 sky130_fd_sc_hd__conb_1_10/HI uio_out[5] 0.08925f
C191 sky130_fd_sc_hd__conb_1_10/HI VDPWR 0.06414f
C192 sky130_fd_sc_hd__conb_1_10/HI uio_out[6] 0.01019f
C193 uio_out[5] sky130_fd_sc_hd__conb_1_11/HI 0.01019f
C194 uio_out[5] uio_out[4] 0.19403f
C195 uio_out[5] VDPWR 0.60019f
C196 uio_out[5] uio_out[6] 0.19403f
C197 sky130_fd_sc_hd__conb_1_21/HI uo_out[2] 0.08925f
C198 sky130_fd_sc_hd__conb_1_21/HI VDPWR 0.06414f
C199 uo_out[2] sky130_fd_sc_hd__conb_1_22/HI 0.01019f
C200 uo_out[2] uo_out[1] 0.19403f
C201 uo_out[2] VDPWR 0.60019f
C202 sky130_fd_sc_hd__buf_2_6/a_27_47# ui_in[3] 0.26287f
C203 sky130_fd_sc_hd__buf_2_6/a_27_47# ui_in[2] 0.01798f
C204 sky130_fd_sc_hd__buf_2_6/a_27_47# VDPWR 0.22424f
C205 sky130_fd_sc_hd__buf_2_6/a_27_47# swA3/G 0.17209f
C206 sky130_fd_sc_hd__buf_2_6/a_27_47# swA4/G 0.01945f
C207 ui_in[3] ui_in[2] 0.17888f
C208 ui_in[3] VDPWR 0.47945f
C209 ui_in[3] swA3/G 0.05431f
C210 ui_in[3] swA4/G 0.15022f
C211 ui_in[3] ui_in[4] 0.17888f
C212 sky130_fd_sc_hd__conb_1_11/HI uio_out[4] 0.08925f
C213 sky130_fd_sc_hd__conb_1_11/HI VDPWR 0.06414f
C214 uio_out[4] sky130_fd_sc_hd__conb_1_12/HI 0.01019f
C215 uio_out[4] uio_out[3] 0.19403f
C216 uio_out[4] VDPWR 0.60019f
C217 sky130_fd_sc_hd__conb_1_22/HI uo_out[1] 0.08925f
C218 sky130_fd_sc_hd__conb_1_22/HI VDPWR 0.06414f
C219 uo_out[1] sky130_fd_sc_hd__conb_1_23/HI 0.01019f
C220 uo_out[1] uo_out[0] 0.19403f
C221 uo_out[1] VDPWR 0.60019f
C222 sky130_fd_sc_hd__buf_2_7/a_27_47# ui_in[2] 0.26287f
C223 sky130_fd_sc_hd__buf_2_7/a_27_47# ui_in[1] 0.01798f
C224 sky130_fd_sc_hd__buf_2_7/a_27_47# VDPWR 0.22424f
C225 sky130_fd_sc_hd__buf_2_7/a_27_47# swA2/G 0.17188f
C226 sky130_fd_sc_hd__buf_2_7/a_27_47# swA4/G 0.01718f
C227 ui_in[2] ui_in[1] 0.17888f
C228 ui_in[2] VDPWR 0.47945f
C229 ui_in[2] swA2/G 0.05431f
C230 ui_in[2] swA3/G 0.09398f
C231 ui_in[2] swA4/G 0.06398f
C232 sky130_fd_sc_hd__conb_1_23/HI uo_out[0] 0.08925f
C233 sky130_fd_sc_hd__conb_1_23/HI VDPWR 0.06414f
C234 uo_out[0] VDPWR 0.61992f
C235 uo_out[0] uio_in[7] 0.03209f
C236 sky130_fd_sc_hd__conb_1_12/HI uio_out[3] 0.08925f
C237 sky130_fd_sc_hd__conb_1_12/HI VDPWR 0.06414f
C238 uio_out[3] sky130_fd_sc_hd__conb_1_13/HI 0.01019f
C239 uio_out[3] uio_out[2] 0.19403f
C240 uio_out[3] VDPWR 0.60019f
C241 sky130_fd_sc_hd__buf_2_8/a_27_47# ui_in[1] 0.26287f
C242 sky130_fd_sc_hd__buf_2_8/a_27_47# ui_in[0] 0.01798f
C243 sky130_fd_sc_hd__buf_2_8/a_27_47# VDPWR 0.22424f
C244 sky130_fd_sc_hd__buf_2_8/a_27_47# swA1/G 0.17212f
C245 sky130_fd_sc_hd__buf_2_8/a_27_47# swA4/G 0.0177f
C246 ui_in[1] ui_in[0] 0.17888f
C247 ui_in[1] VDPWR 0.47945f
C248 ui_in[1] swA1/G 0.05431f
C249 ui_in[1] swA2/G 0.09008f
C250 ui_in[1] swA4/G 0.064f
C251 sky130_fd_sc_hd__conb_1_13/HI uio_out[2] 0.08925f
C252 sky130_fd_sc_hd__conb_1_13/HI VDPWR 0.06414f
C253 uio_out[2] sky130_fd_sc_hd__conb_1_14/HI 0.01019f
C254 uio_out[2] uio_out[1] 0.19403f
C255 uio_out[2] VDPWR 0.60019f
C256 sky130_fd_sc_hd__buf_2_9/a_27_47# ui_in[0] 0.26287f
C257 sky130_fd_sc_hd__buf_2_9/a_27_47# VDPWR 0.22258f
C258 sky130_fd_sc_hd__buf_2_9/a_27_47# swA0/G 0.1702f
C259 sky130_fd_sc_hd__buf_2_9/a_27_47# swA4/G 0.01706f
C260 ui_in[0] VDPWR 0.48104f
C261 ui_in[0] swA0/G 0.05005f
C262 ui_in[0] swA1/G 0.08842f
C263 ui_in[0] swA3/G 0.02458f
C264 ui_in[0] swA4/G 0.07702f
C265 ui_in[0] rst_n 0.03209f
C266 sky130_fd_sc_hd__conb_1_14/HI uio_out[1] 0.08925f
C267 sky130_fd_sc_hd__conb_1_14/HI VDPWR 0.06414f
C268 uio_out[1] sky130_fd_sc_hd__conb_1_15/HI 0.01019f
C269 uio_out[1] uio_out[0] 0.19403f
C270 uio_out[1] VDPWR 0.60019f
C271 sky130_fd_sc_hd__conb_1_15/HI uio_out[0] 0.08925f
C272 sky130_fd_sc_hd__conb_1_15/HI VDPWR 0.06414f
C273 uio_out[0] sky130_fd_sc_hd__conb_1_16/HI 0.01019f
C274 uio_out[0] uo_out[7] 0.19403f
C275 uio_out[0] VDPWR 0.60019f
C276 sky130_fd_sc_hd__conb_1_16/HI uo_out[7] 0.08925f
C277 sky130_fd_sc_hd__conb_1_16/HI VDPWR 0.06414f
C278 uo_out[7] VDPWR 0.60019f
C279 uo_out[7] sky130_fd_sc_hd__conb_1_17/HI 0.01019f
C280 uo_out[7] uo_out[6] 0.19403f
C281 VDPWR sky130_fd_sc_hd__conb_1_0/HI 0.0545f
C282 VDPWR uio_oe[7] 0.58963f
C283 VDPWR sky130_fd_sc_hd__conb_1_17/HI 0.06414f
C284 VDPWR uo_out[6] 0.55595f
C285 VDPWR sky130_fd_sc_hd__conb_1_1/HI 0.06414f
C286 VDPWR uio_oe[6] 0.60019f
C287 VDPWR sky130_fd_sc_hd__conb_1_18/HI 0.06414f
C288 VDPWR uo_out[5] 0.60019f
C289 VDPWR sky130_fd_sc_hd__conb_1_2/HI 0.06414f
C290 VDPWR uio_oe[5] 0.60019f
C291 VDPWR sky130_fd_sc_hd__conb_1_19/HI 0.06414f
C292 VDPWR uo_out[4] 0.60019f
C293 VDPWR sky130_fd_sc_hd__conb_1_3/HI 0.06414f
C294 VDPWR uio_oe[4] 0.60019f
C295 VDPWR swB0/G 0.31203f
C296 VDPWR swB1/G 0.2263f
C297 VDPWR swA0/G 0.22839f
C298 VDPWR sky130_fd_sc_hd__conb_1_4/HI 0.06414f
C299 VDPWR uio_oe[3] 0.60019f
C300 VDPWR sky130_fd_sc_hd__conb_1_5/HI 0.06414f
C301 VDPWR uio_oe[2] 0.60019f
C302 VDPWR swA1/G 0.22053f
C303 VDPWR swB2/G 0.22512f
C304 VDPWR swA2/G 0.22248f
C305 VDPWR swB3/G 0.22424f
C306 VDPWR sky130_fd_sc_hd__conb_1_6/HI 0.06414f
C307 VDPWR uio_oe[1] 0.60019f
C308 VDPWR sky130_fd_sc_hd__conb_1_7/HI 0.06414f
C309 VDPWR uio_oe[0] 0.60019f
C310 VDPWR swA3/G 0.2207f
C311 VDPWR swB4/G 0.22797f
C312 VDPWR sky130_fd_sc_hd__conb_1_8/HI 0.06414f
C313 VDPWR uio_out[7] 0.60019f
C314 VDPWR swA4/G 0.30864f
C315 VDPWR sky130_fd_sc_hd__conb_1_9/HI 0.06414f
C316 VDPWR uio_out[6] 0.60019f
C317 VDPWR uio_in[4] 0.45429f
C318 VDPWR uio_in[3] 0.47945f
C319 VDPWR uio_in[1] 0.47945f
C320 VDPWR uio_in[0] 0.48952f
C321 VDPWR ui_in[4] 0.45392f
C322 sky130_fd_sc_hd__conb_1_0/HI uio_oe[7] 0.08925f
C323 uio_oe[7] sky130_fd_sc_hd__conb_1_1/HI 0.01019f
C324 uio_oe[7] uio_oe[6] 0.19403f
C325 sky130_fd_sc_hd__conb_1_17/HI uo_out[6] 0.08925f
C326 uo_out[6] uo_out[5] 0.19403f
C327 sky130_fd_sc_hd__conb_1_1/HI uio_oe[6] 0.08925f
C328 uio_oe[6] sky130_fd_sc_hd__conb_1_2/HI 0.01019f
C329 uio_oe[6] uio_oe[5] 0.19403f
C330 sky130_fd_sc_hd__conb_1_18/HI uo_out[5] 0.08925f
C331 uo_out[5] sky130_fd_sc_hd__conb_1_19/HI 0.01019f
C332 uo_out[5] uo_out[4] 0.19403f
C333 sky130_fd_sc_hd__conb_1_2/HI uio_oe[5] 0.08925f
C334 uio_oe[5] sky130_fd_sc_hd__conb_1_3/HI 0.01019f
C335 uio_oe[5] uio_oe[4] 0.19403f
C336 sky130_fd_sc_hd__conb_1_19/HI uo_out[4] 0.08925f
C337 sky130_fd_sc_hd__conb_1_3/HI uio_oe[4] 0.08925f
C338 uio_oe[4] sky130_fd_sc_hd__conb_1_4/HI 0.01019f
C339 uio_oe[4] uio_oe[3] 0.19403f
C340 swB0/G swB1/G 17.62998f
C341 swB0/G swA0/G 0.38988f
C342 swB0/G swA1/G 0.08137f
C343 swB0/G swB2/G 0.04476f
C344 swB0/G swA2/G 0.47661f
C345 swB0/G swB3/G 0.04179f
C346 swB0/G swA3/G 0.269f
C347 swB0/G swB4/G 0.05253f
C348 swB0/G swA4/G 0.22604f
C349 swB0/G uio_in[0] 0.05431f
C350 swB0/G ui_in[4] 0.01988f
C351 swB1/G swA0/G 0.08534f
C352 swB1/G swA1/G 0.07148f
C353 swB1/G swB2/G 18.33038f
C354 swB1/G swA2/G 0.06272f
C355 swB1/G swB3/G 0.03469f
C356 swB1/G swA3/G 0.06187f
C357 swB1/G swB4/G 0.04369f
C358 swB1/G swA4/G 0.07727f
C359 swB1/G uio_in[1] 0.05431f
C360 swB1/G uio_in[0] 0.10465f
C361 swA0/G swA1/G 19.66974f
C362 swA0/G swB2/G 0.08534f
C363 swA0/G swA2/G 0.11119f
C364 swA0/G swB3/G 0.08534f
C365 swA0/G swA3/G 0.11443f
C366 swA0/G swB4/G 0.10904f
C367 swA0/G swA4/G 0.79508f
C368 sky130_fd_sc_hd__conb_1_4/HI uio_oe[3] 0.08925f
C369 uio_oe[3] sky130_fd_sc_hd__conb_1_5/HI 0.01019f
C370 uio_oe[3] uio_oe[2] 0.19403f
C371 sky130_fd_sc_hd__conb_1_5/HI uio_oe[2] 0.08925f
C372 uio_oe[2] sky130_fd_sc_hd__conb_1_6/HI 0.01019f
C373 uio_oe[2] uio_oe[1] 0.19403f
C374 swA1/G swB2/G 0.07148f
C375 swA1/G swA2/G 21.41306f
C376 swA1/G swB3/G 0.07148f
C377 swA1/G swA3/G 0.11218f
C378 swA1/G swB4/G 0.09524f
C379 swA1/G swA4/G 0.12171f
C380 swB2/G swA2/G 0.06187f
C381 swB2/G swB3/G 19.13786f
C382 swB2/G swA3/G 0.06156f
C383 swB2/G swB4/G 0.04647f
C384 swB2/G swA4/G 0.07713f
C385 swB2/G uio_in[1] 0.10175f
C386 resarr_0/r_07R1/R1_1 resarr_0/r_07R1/R1_3 0.27149f
C387 resarr_0/r_07R1/R1_1 resarr_0/r_07Rp/R1_31 0.26911f
C388 resarr_0/r_07R1/R2_2 resarr_0/r_07R1/R2_4 0.27121f
C389 resarr_0/r_07R1/R2_2 ua[0] 0.30448f
C390 resarr_0/r_07R1/R1_3 resarr_0/r_07R1/R1_5 0.27149f
C391 resarr_0/r_07R1/R2_4 resarr_0/r_07R1/R2_6 0.27121f
C392 resarr_0/r_07R1/R2_4 ua[0] 0.02138f
C393 resarr_0/r_07R1/R2_6 ua[0] 0.30448f
C394 resarr_0/r_07R2/R2_2 ua[0] 0.30483f
C395 resarr_0/r_05R1/R2_2 ua[0] 0.30483f
C396 resarr_0/r_07Rp/R1_1 resarr_0/r_07Rp/R1_3 0.27121f
C397 ua[0] resarr_0/r_07Rp/R2_2 0.29942f
C398 ua[0] resarr_0/r_07Rp/R2_4 0.01484f
C399 ua[0] resarr_0/r_07Rp/R2_6 0.01618f
C400 ua[0] resarr_0/r_07Rp/R2_8 0.01704f
C401 ua[0] resarr_0/r_07Rp/R2_9 0.01674f
C402 ua[0] resarr_0/r_07Rp/R2_12 0.01653f
C403 ua[0] resarr_0/r_07Rp/R2_14 0.01653f
C404 ua[0] resarr_0/r_07Rp/R2_16 0.01653f
C405 ua[0] resarr_0/r_07Rp/R2_18 0.01653f
C406 ua[0] resarr_0/r_07Rp/R2_20 0.01653f
C407 ua[0] resarr_0/r_07Rp/R2_22 0.01655f
C408 ua[0] resarr_0/r_07Rp/R2_24 0.01692f
C409 ua[0] resarr_0/r_07Rp/R2_26 0.01721f
C410 ua[0] resarr_0/r_07Rp/R2_28 0.01797f
C411 ua[0] resarr_0/r_07Rp/R2_30 0.02138f
C412 resarr_0/r_07Rp/R2_2 resarr_0/r_07Rp/R2_4 0.27121f
C413 resarr_0/r_07Rp/R1_3 resarr_0/r_07Rp/R1_5 0.27121f
C414 resarr_0/r_07Rp/R2_4 resarr_0/r_07Rp/R2_6 0.27121f
C415 resarr_0/r_07Rp/R1_5 resarr_0/r_07Rp/R1_7 0.27121f
C416 resarr_0/r_07Rp/R2_6 resarr_0/r_07Rp/R2_8 0.27121f
C417 resarr_0/r_07Rp/R1_7 resarr_0/r_07Rp/R1_9 0.27121f
C418 resarr_0/r_07Rp/R2_8 resarr_0/r_07Rp/R2_9 0.27121f
C419 resarr_0/r_07Rp/R1_9 resarr_0/r_07Rp/R1_11 0.27121f
C420 resarr_0/r_07Rp/R2_9 resarr_0/r_07Rp/R2_12 0.27121f
C421 resarr_0/r_07Rp/R1_11 resarr_0/r_07Rp/R1_13 0.27121f
C422 resarr_0/r_07Rp/R2_12 resarr_0/r_07Rp/R2_14 0.27121f
C423 resarr_0/r_07Rp/R1_13 resarr_0/r_07Rp/R1_15 0.28249f
C424 resarr_0/r_07Rp/R2_14 resarr_0/r_07Rp/R2_16 0.27121f
C425 resarr_0/r_07Rp/R1_15 resarr_0/r_07Rp/R1_17 0.27121f
C426 resarr_0/r_07Rp/R2_16 resarr_0/r_07Rp/R2_18 0.27121f
C427 resarr_0/r_07Rp/R1_17 resarr_0/r_07Rp/R1_19 0.27121f
C428 resarr_0/r_07Rp/R2_18 resarr_0/r_07Rp/R2_20 0.27121f
C429 resarr_0/r_07Rp/R1_19 resarr_0/r_07Rp/R1_21 0.27121f
C430 resarr_0/r_07Rp/R2_20 resarr_0/r_07Rp/R2_22 0.27121f
C431 resarr_0/r_07Rp/R1_21 resarr_0/r_07Rp/R1_23 0.27121f
C432 resarr_0/r_07Rp/R2_22 resarr_0/r_07Rp/R2_24 0.27121f
C433 resarr_0/r_07Rp/R1_23 resarr_0/r_07Rp/R1_25 0.27121f
C434 resarr_0/r_07Rp/R2_24 resarr_0/r_07Rp/R2_26 0.27121f
C435 resarr_0/r_07Rp/R1_25 resarr_0/r_07Rp/R1_27 0.27121f
C436 resarr_0/r_07Rp/R2_26 resarr_0/r_07Rp/R2_28 0.27121f
C437 resarr_0/r_07Rp/R1_27 resarr_0/r_07Rp/R1_29 0.27121f
C438 resarr_0/r_07Rp/R2_28 resarr_0/r_07Rp/R2_30 0.27121f
C439 resarr_0/r_07Rp/R1_29 resarr_0/r_07Rp/R1_31 0.27121f
C440 swA2/G swB3/G 0.06156f
C441 swA2/G swA3/G 22.23183f
C442 swA2/G swB4/G 0.08518f
C443 swA2/G swA4/G 0.11093f
C444 swB3/G swA3/G 0.06142f
C445 swB3/G swB4/G 20.29155f
C446 swB3/G swA4/G 0.07706f
C447 swB3/G uio_in[3] 0.05431f
C448 sky130_fd_sc_hd__conb_1_6/HI uio_oe[1] 0.08925f
C449 uio_oe[1] sky130_fd_sc_hd__conb_1_7/HI 0.01019f
C450 uio_oe[1] uio_oe[0] 0.19403f
C451 sky130_fd_sc_hd__conb_1_7/HI uio_oe[0] 0.08925f
C452 uio_oe[0] sky130_fd_sc_hd__conb_1_8/HI 0.01019f
C453 uio_oe[0] uio_out[7] 0.19403f
C454 swA3/G swB4/G 0.08511f
C455 swA3/G swA4/G 23.40039f
C456 swB4/G swA4/G 0.1621f
C457 swB4/G uio_in[4] 0.05431f
C458 swB4/G uio_in[3] 0.09803f
C459 sky130_fd_sc_hd__conb_1_8/HI uio_out[7] 0.08925f
C460 uio_out[7] sky130_fd_sc_hd__conb_1_9/HI 0.01019f
C461 uio_out[7] uio_out[6] 0.19403f
C462 swA4/G ui_in[4] 0.05549f
C463 sky130_fd_sc_hd__conb_1_9/HI uio_out[6] 0.08925f
C464 uio_in[4] uio_in[3] 0.17888f
C465 uio_in[4] uio_in[5] 0.03209f
C466 uio_in[1] uio_in[0] 0.17888f
C467 uio_in[0] ui_in[7] 0.03209f
C468 ui_in[4] ui_in[5] 0.03209f
C469 uio_in[7] uio_in[6] 0.03103f
C470 uio_in[6] uio_in[5] 0.03103f
C471 ui_in[7] ui_in[6] 0.03103f
C472 ui_in[6] ui_in[5] 0.03103f
C473 rst_n clk 0.03103f
C474 clk ena 0.03103f
C475 ua[2] VGND 0.14023f
C476 ua[3] VGND 0.14023f
C477 ua[4] VGND 0.14023f
C478 ua[5] VGND 0.14023f
C479 ua[6] VGND 0.14023f
C480 ua[7] VGND 0.14023f
C481 ena VGND 0.0637f
C482 clk VGND 0.03988f
C483 rst_n VGND 0.03805f
C484 ui_in[5] VGND 0.03803f
C485 ui_in[6] VGND 0.03834f
C486 ui_in[7] VGND 0.03803f
C487 uio_in[5] VGND 0.03824f
C488 uio_in[6] VGND 0.03856f
C489 uio_in[7] VGND 0.03824f
C490 ui_in[4] VGND 0.6335f
C491 uio_in[0] VGND 0.63685f
C492 uio_in[1] VGND 0.53138f
C493 uio_in[3] VGND 0.53288f
C494 uio_in[4] VGND 0.6507f
C495 uio_out[6] VGND 0.32779f
C496 sky130_fd_sc_hd__conb_1_9/HI VGND 0.42842f
C497 swA4/G VGND 7.31571f
C498 uio_out[7] VGND 0.32779f
C499 sky130_fd_sc_hd__conb_1_8/HI VGND 0.42842f
C500 swB4/G VGND 7.42397f
C501 swA3/G VGND 3.30099f
C502 uio_oe[0] VGND 0.32779f
C503 sky130_fd_sc_hd__conb_1_7/HI VGND 0.42868f
C504 uio_oe[1] VGND 0.32779f
C505 sky130_fd_sc_hd__conb_1_6/HI VGND 0.42842f
C506 swB3/G VGND 3.03637f
C507 swA2/G VGND 2.40012f
C508 resarr_0/r_05Rp/R1_1 VGND 0.68806f ; **FLOATING
C509 resarr_0/r_07Rp/R1_31 VGND 0.34822f ; **FLOATING
C510 resarr_0/r_07Rp/R2_30 VGND 0.61533f ; **FLOATING
C511 resarr_0/r_07Rp/R1_29 VGND 0.34689f ; **FLOATING
C512 resarr_0/r_07Rp/R2_28 VGND 0.34387f ; **FLOATING
C513 resarr_0/r_07Rp/R1_27 VGND 0.34689f ; **FLOATING
C514 resarr_0/r_07Rp/R2_26 VGND 0.34385f ; **FLOATING
C515 resarr_0/r_07Rp/R1_25 VGND 0.34689f ; **FLOATING
C516 resarr_0/r_07Rp/R2_24 VGND 0.34384f ; **FLOATING
C517 resarr_0/r_07Rp/R1_23 VGND 0.34689f ; **FLOATING
C518 resarr_0/r_07Rp/R2_22 VGND 0.34373f ; **FLOATING
C519 resarr_0/r_07Rp/R1_21 VGND 0.34689f ; **FLOATING
C520 resarr_0/r_07Rp/R2_20 VGND 0.34383f ; **FLOATING
C521 resarr_0/r_07Rp/R1_19 VGND 0.34689f ; **FLOATING
C522 resarr_0/r_07Rp/R2_18 VGND 0.34383f ; **FLOATING
C523 resarr_0/r_07Rp/R1_17 VGND 0.34689f ; **FLOATING
C524 resarr_0/r_07Rp/R2_16 VGND 0.34383f ; **FLOATING
C525 resarr_0/r_07Rp/R1_15 VGND 0.31928f ; **FLOATING
C526 resarr_0/r_07Rp/R2_14 VGND 0.31652f ; **FLOATING
C527 resarr_0/r_07Rp/R1_13 VGND 0.34689f ; **FLOATING
C528 resarr_0/r_07Rp/R2_12 VGND 0.34383f ; **FLOATING
C529 resarr_0/r_07Rp/R1_11 VGND 0.34689f ; **FLOATING
C530 resarr_0/r_07Rp/R2_9 VGND 0.34383f ; **FLOATING
C531 resarr_0/r_07Rp/R1_9 VGND 0.34689f ; **FLOATING
C532 resarr_0/r_07Rp/R2_8 VGND 0.34384f ; **FLOATING
C533 resarr_0/r_07Rp/R1_7 VGND 0.3469f ; **FLOATING
C534 resarr_0/r_07Rp/R2_6 VGND 0.34384f ; **FLOATING
C535 resarr_0/r_07Rp/R1_5 VGND 0.34707f ; **FLOATING
C536 resarr_0/r_07Rp/R2_4 VGND 0.34386f ; **FLOATING
C537 resarr_0/r_07Rp/R1_3 VGND 0.34693f ; **FLOATING
C538 resarr_0/r_07Rp/R2_2 VGND 0.3439f ; **FLOATING
C539 ua[0] VGND 36.61981f
C540 resarr_0/r_07Rp/R1_1 VGND 0.52649f ; **FLOATING
C541 resarr_0/r_05R1/R2_2 VGND 0.34399f ; **FLOATING
C542 resarr_0/r_05R1/R1_1 VGND 0.53049f ; **FLOATING
C543 resarr_0/r_07R2/R2_2 VGND 0.34392f ; **FLOATING
C544 resarr_0/r_07R2/R1_1 VGND 0.50305f ; **FLOATING
C545 resarr_0/r_07R1/R2_6 VGND 0.34386f ; **FLOATING
C546 resarr_0/r_07R1/R1_5 VGND 0.34736f ; **FLOATING
C547 resarr_0/r_07R1/R2_4 VGND 0.34386f ; **FLOATING
C548 resarr_0/r_07R1/R1_3 VGND 0.34723f ; **FLOATING
C549 resarr_0/r_07R1/R2_2 VGND 0.34392f ; **FLOATING
C550 resarr_0/r_07R1/R1_1 VGND 0.34879f ; **FLOATING
C551 swB2/G VGND 2.19726f
C552 swA1/G VGND 2.25546f
C553 uio_oe[2] VGND 0.32779f
C554 sky130_fd_sc_hd__conb_1_5/HI VGND 0.42842f
C555 uio_oe[3] VGND 0.32779f
C556 sky130_fd_sc_hd__conb_1_4/HI VGND 0.42842f
C557 swA0/G VGND 3.78182f
C558 swB1/G VGND 1.85592f
C559 swB0/G VGND 2.24238f
C560 uio_oe[4] VGND 0.32775f
C561 sky130_fd_sc_hd__conb_1_3/HI VGND 0.42842f
C562 uo_out[4] VGND 0.32779f
C563 sky130_fd_sc_hd__conb_1_19/HI VGND 0.42842f
C564 uio_oe[5] VGND 0.32779f
C565 sky130_fd_sc_hd__conb_1_2/HI VGND 0.42842f
C566 uo_out[5] VGND 0.32779f
C567 sky130_fd_sc_hd__conb_1_18/HI VGND 0.42865f
C568 uio_oe[6] VGND 0.32779f
C569 sky130_fd_sc_hd__conb_1_1/HI VGND 0.42842f
C570 uo_out[6] VGND 0.36964f
C571 sky130_fd_sc_hd__conb_1_17/HI VGND 0.42842f
C572 uio_oe[7] VGND 0.49535f
C573 sky130_fd_sc_hd__conb_1_0/HI VGND 0.41107f
C574 VDPWR VGND 63.14111f
C575 uo_out[7] VGND 0.32779f
C576 sky130_fd_sc_hd__conb_1_16/HI VGND 0.42842f
C577 uio_out[0] VGND 0.32779f
C578 sky130_fd_sc_hd__conb_1_15/HI VGND 0.42842f
C579 uio_out[1] VGND 0.32782f
C580 sky130_fd_sc_hd__conb_1_14/HI VGND 0.42842f
C581 ui_in[0] VGND 0.63647f
C582 sky130_fd_sc_hd__buf_2_9/a_27_47# VGND 0.31327f ; **FLOATING
C583 uio_out[2] VGND 0.32779f
C584 sky130_fd_sc_hd__conb_1_13/HI VGND 0.42842f
C585 ui_in[1] VGND 0.52785f
C586 sky130_fd_sc_hd__buf_2_8/a_27_47# VGND 0.31351f ; **FLOATING
C587 uio_out[3] VGND 0.32779f
C588 sky130_fd_sc_hd__conb_1_12/HI VGND 0.42842f
C589 uo_out[0] VGND 0.45499f
C590 sky130_fd_sc_hd__conb_1_23/HI VGND 0.42842f
C591 ui_in[2] VGND 0.52822f
C592 sky130_fd_sc_hd__buf_2_7/a_27_47# VGND 0.3136f ; **FLOATING
C593 uo_out[1] VGND 0.32779f
C594 sky130_fd_sc_hd__conb_1_22/HI VGND 0.42842f
C595 uio_out[4] VGND 0.32779f
C596 sky130_fd_sc_hd__conb_1_11/HI VGND 0.42842f
C597 ui_in[3] VGND 0.52818f
C598 sky130_fd_sc_hd__buf_2_6/a_27_47# VGND 0.31409f ; **FLOATING
C599 uo_out[2] VGND 0.32779f
C600 sky130_fd_sc_hd__conb_1_21/HI VGND 0.42842f
C601 uio_out[5] VGND 0.32779f
C602 sky130_fd_sc_hd__conb_1_10/HI VGND 0.42842f
C603 ua[1] VGND 35.59146f
C604 swB3/S3 VGND 51.83846f ; **FLOATING
C605 swB2/S1 VGND 27.30421f ; **FLOATING
C606 swB1/S1 VGND 14.89297f ; **FLOATING
C607 swB0/S1 VGND 12.39695f ; **FLOATING
C608 swB4/S7 VGND 0.1051p ; **FLOATING
C609 blk05_0/n05_1 VGND 1.3751p ; **FLOATING
C610 blk05_0/n05_3 VGND 0.62014p ; **FLOATING
C611 blk05_0/n05_2 VGND 1.23891p ; **FLOATING
C612 sky130_fd_sc_hd__buf_2_5/a_27_47# VGND 0.31372f ; **FLOATING
C613 uo_out[3] VGND 0.32779f
C614 sky130_fd_sc_hd__conb_1_20/HI VGND 0.42842f
C615 sky130_fd_sc_hd__buf_2_4/a_27_47# VGND 0.31453f ; **FLOATING
C616 sky130_fd_sc_hd__buf_2_3/a_27_47# VGND 0.31376f ; **FLOATING
C617 swA3/S3 VGND 52.28009f ; **FLOATING
C618 swA2/S1 VGND 27.57903f ; **FLOATING
C619 swA1/S1 VGND 15.10043f ; **FLOATING
C620 swA0/S1 VGND 12.07694f ; **FLOATING
C621 swA4/S7 VGND 0.10458p ; **FLOATING
C622 blk07_0/n07_3 VGND 0.45024p ; **FLOATING
C623 blk07_0/n07_2 VGND 0.6777p ; **FLOATING
C624 blk07_0/n07_1 VGND 1.49953p ; **FLOATING
C625 blk07_0/n07_5 VGND 0.46385p ; **FLOATING
C626 blk07_0/n07_4 VGND 0.27707p ; **FLOATING
C627 uio_in[2] VGND 0.53229f
C628 sky130_fd_sc_hd__buf_2_2/a_27_47# VGND 0.31376f ; **FLOATING
C629 sky130_fd_sc_hd__buf_2_1/a_27_47# VGND 0.31376f ; **FLOATING
C630 sky130_fd_sc_hd__buf_2_0/a_27_47# VGND 0.3152f ; **FLOATING
.ends
